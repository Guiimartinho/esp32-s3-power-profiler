* VIN terminal from -20 V to +20 V, instrument idle
.include "../../models/path_switching.lib"
.include "../../models/mosfets.lib"
.include "../../models/diodes.lib"
.include "../../models/logic.lib"
XF1 vin_raw vin_p PATH_FUSE_0466004
MQ2 amp_in gate_src 0 PATH_BSS138
MQ3 amp_in vin_ov 0 PATH_BSS138
MQ4 ldo_out g_src s_src CSD17577Q3A
MQ5 vin_p g_amp s_amp CSD17577Q3A
QQ6 g_src b_src s_src PATH_BC847B
QQ7 g_amp b_amp s_amp PATH_BC847B
MQ8 supply g_src s_src CSD17577Q3A
MQ9 supply g_amp s_amp CSD17577Q3A
C56 p12v_a 0 1e-06
C57 p12v_a 0 1e-07
C58 det 0 1e-09
C59 p3v3_a 0 1e-07
C60 g_src ramp_src 1e-07
C61 g_amp ramp_amp 1e-07
C62 supply 0 1e-06
C63 damper 0 4.7e-06
C71 vout_s 0 1e-07
XD14 vin_p 0 PATH_SMAJ20CA
DD15_1 0 det BAV199
DD15_2 det p3v3_a BAV199
DD16_1 g_src off_src BAV199
DD16_2 off_src p12v_a BAV199
DD17_1 g_amp off_amp BAV199
DD17_2 off_amp p12v_a BAV199
DD18_1 s_src b_src BAV199
DD18_2 b_src b_src BAV199
DD19_1 s_amp b_amp BAV199
DD19_2 b_amp b_amp BAV199
R70 gate_src 0 1000
R71 gate_amp 0 4700
R72 gate_amp amp_in 1000
R73 vin_p det 115000
R74 det 0 100000
R75 gate_src src_in 1000
R76 det vin_ov 3.3e+06
R77 drv_src off_src 22
R78 drv_src g_src 100000
R79 drv_amp off_amp 22
R80 drv_amp g_amp 100000
R81 ramp_src 0 6800
R82 ramp_amp 0 6800
R83 g_src s_src 2.2e+06
R84 g_amp s_amp 2.2e+06
R85 b_src 0 100000
R86 b_amp 0 100000
R87 supply damper 0.47
R90 supply 0 100000
XU20_1 src_in drv_src p12v_a 0 TC4427CH
XU20_2 amp_in drv_amp p12v_a 0 TC4427CH
XU21 det vref vin_ov p3v3_a 0 MCP656X
C104 vin_mon 0 1e-07
R101 supply vout_s 1000
R141 vin_p vin_mon 430000
R150 vin_mon 0 10000
* ideal rails
Vp12 p12v_a 0 12
Vm4 m4v_a 0 -4
Vp3v3a p3v3_a 0 3.3
Vref vref 0 2.5
* the terminal driven by a source without leads
Vin vin_src 0 PWL(0 0 0.04 20 0.05 20 0.09 0 0.13 -20 0.14 -20 0.18 0)
Vlead vin_src vin_raw 0
* regulator output at rest: its minimum load and capacitor hold it at 0 V
Rldo ldo_out 0 1
* mode requests: pins of the controller behind their output resistance
Vsrc pin_src 0 PWL(0 0)
Rpad_src pin_src gate_src 33
Vamp pin_amp 0 PWL(0 0)
Rpad_amp pin_amp gate_amp 33
.control
save vin_p det vin_ov g_amp s_amp b_amp supply ldo_out amp_in vin_mon vlead#branch @qq7[ic] @qq7[ib] @d.xd14.d1[id] @dd15_1[id] @dd15_2[id] @mq5[id]
tran 20u 0.18 0 50u
.endc
.end
