* Monitor scan: eight channels at 100 SPS each, five cycles
.include "../../models/digital.lib"
RRN1_1 gp12 c_miso 2200
RRN1_2 gp13 c_mon_cs 2200
RRN1_3 gp14 c_sck 2200
RRN1_4 gp15 c_mosi 2200
RRN2_1 c_miso 0 4700
RRN2_2 gp13 v3a 4700
RRN2_3 gp14 0 4700
RRN2_4 gp15 0 4700
XU15_1 c_dac_cs v3a 0 DIGITAL_INPUT_PIN
XU15_2 c_sck v3a 0 DIGITAL_INPUT_PIN
XU15_3 c_mosi v3a 0 DIGITAL_INPUT_PIN
XU39 v3a temp_out 0 DIGITAL_MCP9700A
XU40 ch0 ch1 ch2 ch3 ch4 ch5 ch6 ch7 0 c_mon_cs c_mosi c_miso c_sck 0 vref v3a DIGITAL_MCP3208
C102 v3a 0 1e-07
C103 ch0 0 1e-07
C104 ch1 0 1e-07
C105 ch2 0 1e-07
C106 ch3 0 1e-07
C107 ch4 0 1e-07
C108 ch5 0 1e-07
C109 ch6 0 1e-07
C110 ch7 0 1e-07
C111 v3a 0 1e-07
C112 v3a 0 1e-06
C113 vref 0 1e-07
R140 vout_buf ch0 120000
R141 vin_p ch1 430000
R142 v5 ch2 120000
R143 ch2 src_st 68100
R144 cc1 ch3 10000
R145 cc2 ch4 10000
R146 temp_out ch5 1000
R147 v12 ch6 47000
R148 vref ch7 100000
R149 ch0 0 100000
R150 ch1 0 10000
R151 ch2 0 100000
R152 ch6 0 10000
R153 ch7 vm4 200000
* what the channels read, as ideal sources
Vout vout_buf 0 5.5
Vin vin_p 0 5
Vrail v5 0 5
Vcc1 cc1 0 0.92
Vcc2 cc2 0 0
Vp12 v12 0 12
Vm4 vm4 0 -4
Vref vref 0 2.5
Vanalog v3a 0 3.3
* the select of the DAC rests high; its pad and resistors are not here
Vdac c_dac_cs 0 3.3
* the 3.3 V rail of the module, an ideal source
Viovdd iovdd 0 3.3
* three pads of the controller drive the bus, one reads
Xgp13 gp13 gp13_ctl gp13_oe iovdd 0 DIGITAL_RP2350_PAD roh=170 rol=125 cpad=5e-12 e9=0
Xgp14 gp14 gp14_ctl gp14_oe iovdd 0 DIGITAL_RP2350_PAD roh=170 rol=125 cpad=5e-12 e9=0
Xgp15 gp15 gp15_ctl gp15_oe iovdd 0 DIGITAL_RP2350_PAD roh=170 rol=125 cpad=5e-12 e9=0
Xgp12 gp12 gp12_ctl gp12_oe iovdd 0 DIGITAL_RP2350_PAD roh=170 rol=125 cpad=5e-12 e9=0
Vgp13_ctl gp13_ctl 0 PWL(0 1 0.0002 1 0.000200005 0 0.000239 0 0.000239005 1 0.00145 1 0.001450005 0 0.001489 0 0.001489005 1 0.0027 1 0.002700005 0 0.002739 0 0.002739005 1 0.00395 1 0.003950005 0 0.003989 0 0.003989005 1 0.0052 1 0.005200005 0 0.005239 0 0.005239005 1 0.00645 1 0.006450005 0 0.006489 0 0.006489005 1 0.0077 1 0.007700005 0 0.007739 0 0.007739005 1 0.00895 1 0.008950005 0 0.008989 0 0.008989005 1 0.0102 1 0.010200005 0 0.010239 0 0.010239005 1 0.01145 1 0.011450005 0 0.011489 0 0.011489005 1 0.0127 1 0.012700005 0 0.012739 0 0.012739005 1 0.01395 1 0.013950005 0 0.013989 0 0.013989005 1 0.0152 1 0.015200005 0 0.015239 0 0.015239005 1 0.01645 1 0.016450005 0 0.016489 0 0.016489005 1 0.0177 1 0.017700005 0 0.017739 0 0.017739005 1 0.01895 1 0.018950005 0 0.018989 0 0.018989005 1 0.0202 1 0.020200005 0 0.020239 0 0.020239005 1 0.02145 1 0.021450005 0 0.021489 0 0.021489005 1 0.0227 1 0.022700005 0 0.022739 0 0.022739005 1 0.02395 1 0.023950005 0 0.023989 0 0.023989005 1 0.0252 1 0.025200005 0 0.025239 0 0.025239005 1 0.02645 1 0.026450005 0 0.026489 0 0.026489005 1 0.0277 1 0.027700005 0 0.027739 0 0.027739005 1 0.02895 1 0.028950005 0 0.028989 0 0.028989005 1 0.0302 1 0.030200005 0 0.030239 0 0.030239005 1 0.03145 1 0.031450005 0 0.031489 0 0.031489005 1 0.0327 1 0.032700005 0 0.032739 0 0.032739005 1 0.03395 1 0.033950005 0 0.033989 0 0.033989005 1 0.0352 1 0.035200005 0 0.035239 0 0.035239005 1 0.03645 1 0.036450005 0 0.036489 0 0.036489005 1 0.0377 1 0.037700005 0 0.037739 0 0.037739005 1 0.03895 1 0.038950005 0 0.038989 0 0.038989005 1 0.0402 1 0.040200005 0 0.040239 0 0.040239005 1 0.04145 1 0.041450005 0 0.041489 0 0.041489005 1 0.0427 1 0.042700005 0 0.042739 0 0.042739005 1 0.04395 1 0.043950005 0 0.043989 0 0.043989005 1 0.0452 1 0.045200005 0 0.045239 0 0.045239005 1 0.04645 1 0.046450005 0 0.046489 0 0.046489005 1 0.0477 1 0.047700005 0 0.047739 0 0.047739005 1 0.04895 1 0.048950005 0 0.048989 0 0.048989005 1)
Vgp14_ctl gp14_ctl 0 PWL(0 0 0.000201 0 0.000201005 1 0.000202 1 0.000202005 0 0.000203 0 0.000203005 1 0.000204 1 0.000204005 0 0.000205 0 0.000205005 1 0.000206 1 0.000206005 0 0.000207 0 0.000207005 1 0.000208 1 0.000208005 0 0.000209 0 0.000209005 1 0.00021 1 0.000210005 0 0.000211 0 0.000211005 1 0.000212 1 0.000212005 0 0.000213 0 0.000213005 1 0.000214 1 0.000214005 0 0.000215 0 0.000215005 1 0.000216 1 0.000216005 0 0.000217 0 0.000217005 1 0.000218 1 0.000218005 0 0.000219 0 0.000219005 1 0.00022 1 0.000220005 0 0.000221 0 0.000221005 1 0.000222 1 0.000222005 0 0.000223 0 0.000223005 1 0.000224 1 0.000224005 0 0.000225 0 0.000225005 1 0.000226 1 0.000226005 0 0.000227 0 0.000227005 1 0.000228 1 0.000228005 0 0.000229 0 0.000229005 1 0.00023 1 0.000230005 0 0.000231 0 0.000231005 1 0.000232 1 0.000232005 0 0.000233 0 0.000233005 1 0.000234 1 0.000234005 0 0.000235 0 0.000235005 1 0.000236 1 0.000236005 0 0.000237 0 0.000237005 1 0.000238 1 0.000238005 0 0.001451 0 0.001451005 1 0.001452 1 0.001452005 0 0.001453 0 0.001453005 1 0.001454 1 0.001454005 0 0.001455 0 0.001455005 1 0.001456 1 0.001456005 0 0.001457 0 0.001457005 1 0.001458 1 0.001458005 0 0.001459 0 0.001459005 1 0.00146 1 0.001460005 0 0.001461 0 0.001461005 1 0.001462 1 0.001462005 0 0.001463 0 0.001463005 1 0.001464 1 0.001464005 0 0.001465 0 0.001465005 1 0.001466 1 0.001466005 0 0.001467 0 0.001467005 1 0.001468 1 0.001468005 0 0.001469 0 0.001469005 1 0.00147 1 0.001470005 0 0.001471 0 0.001471005 1 0.001472 1 0.001472005 0 0.001473 0 0.001473005 1 0.001474 1 0.001474005 0 0.001475 0 0.001475005 1 0.001476 1 0.001476005 0 0.001477 0 0.001477005 1 0.001478 1 0.001478005 0 0.001479 0 0.001479005 1 0.00148 1 0.001480005 0 0.001481 0 0.001481005 1 0.001482 1 0.001482005 0 0.001483 0 0.001483005 1 0.001484 1 0.001484005 0 0.001485 0 0.001485005 1 0.001486 1 0.001486005 0 0.001487 0 0.001487005 1 0.001488 1 0.001488005 0 0.002701 0 0.002701005 1 0.002702 1 0.002702005 0 0.002703 0 0.002703005 1 0.002704 1 0.002704005 0 0.002705 0 0.002705005 1 0.002706 1 0.002706005 0 0.002707 0 0.002707005 1 0.002708 1 0.002708005 0 0.002709 0 0.002709005 1 0.00271 1 0.002710005 0 0.002711 0 0.002711005 1 0.002712 1 0.002712005 0 0.002713 0 0.002713005 1 0.002714 1 0.002714005 0 0.002715 0 0.002715005 1 0.002716 1 0.002716005 0 0.002717 0 0.002717005 1 0.002718 1 0.002718005 0 0.002719 0 0.002719005 1 0.00272 1 0.002720005 0 0.002721 0 0.002721005 1 0.002722 1 0.002722005 0 0.002723 0 0.002723005 1 0.002724 1 0.002724005 0 0.002725 0 0.002725005 1 0.002726 1 0.002726005 0 0.002727 0 0.002727005 1 0.002728 1 0.002728005 0 0.002729 0 0.002729005 1 0.00273 1 0.002730005 0 0.002731 0 0.002731005 1 0.002732 1 0.002732005 0 0.002733 0 0.002733005 1 0.002734 1 0.002734005 0 0.002735 0 0.002735005 1 0.002736 1 0.002736005 0 0.002737 0 0.002737005 1 0.002738 1 0.002738005 0 0.003951 0 0.003951005 1 0.003952 1 0.003952005 0 0.003953 0 0.003953005 1 0.003954 1 0.003954005 0 0.003955 0 0.003955005 1 0.003956 1 0.003956005 0 0.003957 0 0.003957005 1 0.003958 1 0.003958005 0 0.003959 0 0.003959005 1 0.00396 1 0.003960005 0 0.003961 0 0.003961005 1 0.003962 1 0.003962005 0 0.003963 0 0.003963005 1 0.003964 1 0.003964005 0 0.003965 0 0.003965005 1 0.003966 1 0.003966005 0 0.003967 0 0.003967005 1 0.003968 1 0.003968005 0 0.003969 0 0.003969005 1 0.00397 1 0.003970005 0 0.003971 0 0.003971005 1 0.003972 1 0.003972005 0 0.003973 0 0.003973005 1 0.003974 1 0.003974005 0 0.003975 0 0.003975005 1 0.003976 1 0.003976005 0 0.003977 0 0.003977005 1 0.003978 1 0.003978005 0 0.003979 0 0.003979005 1 0.00398 1 0.003980005 0 0.003981 0 0.003981005 1 0.003982 1 0.003982005 0 0.003983 0 0.003983005 1 0.003984 1 0.003984005 0 0.003985 0 0.003985005 1 0.003986 1 0.003986005 0 0.003987 0 0.003987005 1 0.003988 1 0.003988005 0 0.005201 0 0.005201005 1 0.005202 1 0.005202005 0 0.005203 0 0.005203005 1 0.005204 1 0.005204005 0 0.005205 0 0.005205005 1 0.005206 1 0.005206005 0 0.005207 0 0.005207005 1 0.005208 1 0.005208005 0 0.005209 0 0.005209005 1 0.00521 1 0.005210005 0 0.005211 0 0.005211005 1 0.005212 1 0.005212005 0 0.005213 0 0.005213005 1 0.005214 1 0.005214005 0 0.005215 0 0.005215005 1 0.005216 1 0.005216005 0 0.005217 0 0.005217005 1 0.005218 1 0.005218005 0 0.005219 0 0.005219005 1 0.00522 1 0.005220005 0 0.005221 0 0.005221005 1 0.005222 1 0.005222005 0 0.005223 0 0.005223005 1 0.005224 1 0.005224005 0 0.005225 0 0.005225005 1 0.005226 1 0.005226005 0 0.005227 0 0.005227005 1 0.005228 1 0.005228005 0 0.005229 0 0.005229005 1 0.00523 1 0.005230005 0 0.005231 0 0.005231005 1 0.005232 1 0.005232005 0 0.005233 0 0.005233005 1 0.005234 1 0.005234005 0 0.005235 0 0.005235005 1 0.005236 1 0.005236005 0 0.005237 0 0.005237005 1 0.005238 1 0.005238005 0 0.006451 0 0.006451005 1 0.006452 1 0.006452005 0 0.006453 0 0.006453005 1 0.006454 1 0.006454005 0 0.006455 0 0.006455005 1 0.006456 1 0.006456005 0 0.006457 0 0.006457005 1 0.006458 1 0.006458005 0 0.006459 0 0.006459005 1 0.00646 1 0.006460005 0 0.006461 0 0.006461005 1 0.006462 1 0.006462005 0 0.006463 0 0.006463005 1 0.006464 1 0.006464005 0 0.006465 0 0.006465005 1 0.006466 1 0.006466005 0 0.006467 0 0.006467005 1 0.006468 1 0.006468005 0 0.006469 0 0.006469005 1 0.00647 1 0.006470005 0 0.006471 0 0.006471005 1 0.006472 1 0.006472005 0 0.006473 0 0.006473005 1 0.006474 1 0.006474005 0 0.006475 0 0.006475005 1 0.006476 1 0.006476005 0 0.006477 0 0.006477005 1 0.006478 1 0.006478005 0 0.006479 0 0.006479005 1 0.00648 1 0.006480005 0 0.006481 0 0.006481005 1 0.006482 1 0.006482005 0 0.006483 0 0.006483005 1 0.006484 1 0.006484005 0 0.006485 0 0.006485005 1 0.006486 1 0.006486005 0 0.006487 0 0.006487005 1 0.006488 1 0.006488005 0 0.007701 0 0.007701005 1 0.007702 1 0.007702005 0 0.007703 0 0.007703005 1 0.007704 1 0.007704005 0 0.007705 0 0.007705005 1 0.007706 1 0.007706005 0 0.007707 0 0.007707005 1 0.007708 1 0.007708005 0 0.007709 0 0.007709005 1 0.00771 1 0.007710005 0 0.007711 0 0.007711005 1 0.007712 1 0.007712005 0 0.007713 0 0.007713005 1 0.007714 1 0.007714005 0 0.007715 0 0.007715005 1 0.007716 1 0.007716005 0 0.007717 0 0.007717005 1 0.007718 1 0.007718005 0 0.007719 0 0.007719005 1 0.00772 1 0.007720005 0 0.007721 0 0.007721005 1 0.007722 1 0.007722005 0 0.007723 0 0.007723005 1 0.007724 1 0.007724005 0 0.007725 0 0.007725005 1 0.007726 1 0.007726005 0 0.007727 0 0.007727005 1 0.007728 1 0.007728005 0 0.007729 0 0.007729005 1 0.00773 1 0.007730005 0 0.007731 0 0.007731005 1 0.007732 1 0.007732005 0 0.007733 0 0.007733005 1 0.007734 1 0.007734005 0 0.007735 0 0.007735005 1 0.007736 1 0.007736005 0 0.007737 0 0.007737005 1 0.007738 1 0.007738005 0 0.008951 0 0.008951005 1 0.008952 1 0.008952005 0 0.008953 0 0.008953005 1 0.008954 1 0.008954005 0 0.008955 0 0.008955005 1 0.008956 1 0.008956005 0 0.008957 0 0.008957005 1 0.008958 1 0.008958005 0 0.008959 0 0.008959005 1 0.00896 1 0.008960005 0 0.008961 0 0.008961005 1 0.008962 1 0.008962005 0 0.008963 0 0.008963005 1 0.008964 1 0.008964005 0 0.008965 0 0.008965005 1 0.008966 1 0.008966005 0 0.008967 0 0.008967005 1 0.008968 1 0.008968005 0 0.008969 0 0.008969005 1 0.00897 1 0.008970005 0 0.008971 0 0.008971005 1 0.008972 1 0.008972005 0 0.008973 0 0.008973005 1 0.008974 1 0.008974005 0 0.008975 0 0.008975005 1 0.008976 1 0.008976005 0 0.008977 0 0.008977005 1 0.008978 1 0.008978005 0 0.008979 0 0.008979005 1 0.00898 1 0.008980005 0 0.008981 0 0.008981005 1 0.008982 1 0.008982005 0 0.008983 0 0.008983005 1 0.008984 1 0.008984005 0 0.008985 0 0.008985005 1 0.008986 1 0.008986005 0 0.008987 0 0.008987005 1 0.008988 1 0.008988005 0 0.010201 0 0.010201005 1 0.010202 1 0.010202005 0 0.010203 0 0.010203005 1 0.010204 1 0.010204005 0 0.010205 0 0.010205005 1 0.010206 1 0.010206005 0 0.010207 0 0.010207005 1 0.010208 1 0.010208005 0 0.010209 0 0.010209005 1 0.01021 1 0.010210005 0 0.010211 0 0.010211005 1 0.010212 1 0.010212005 0 0.010213 0 0.010213005 1 0.010214 1 0.010214005 0 0.010215 0 0.010215005 1 0.010216 1 0.010216005 0 0.010217 0 0.010217005 1 0.010218 1 0.010218005 0 0.010219 0 0.010219005 1 0.01022 1 0.010220005 0 0.010221 0 0.010221005 1 0.010222 1 0.010222005 0 0.010223 0 0.010223005 1 0.010224 1 0.010224005 0 0.010225 0 0.010225005 1 0.010226 1 0.010226005 0 0.010227 0 0.010227005 1 0.010228 1 0.010228005 0 0.010229 0 0.010229005 1 0.01023 1 0.010230005 0 0.010231 0 0.010231005 1 0.010232 1 0.010232005 0 0.010233 0 0.010233005 1 0.010234 1 0.010234005 0 0.010235 0 0.010235005 1 0.010236 1 0.010236005 0 0.010237 0 0.010237005 1 0.010238 1 0.010238005 0 0.011451 0 0.011451005 1 0.011452 1 0.011452005 0 0.011453 0 0.011453005 1 0.011454 1 0.011454005 0 0.011455 0 0.011455005 1 0.011456 1 0.011456005 0 0.011457 0 0.011457005 1 0.011458 1 0.011458005 0 0.011459 0 0.011459005 1 0.01146 1 0.011460005 0 0.011461 0 0.011461005 1 0.011462 1 0.011462005 0 0.011463 0 0.011463005 1 0.011464 1 0.011464005 0 0.011465 0 0.011465005 1 0.011466 1 0.011466005 0 0.011467 0 0.011467005 1 0.011468 1 0.011468005 0 0.011469 0 0.011469005 1 0.01147 1 0.011470005 0 0.011471 0 0.011471005 1 0.011472 1 0.011472005 0 0.011473 0 0.011473005 1 0.011474 1 0.011474005 0 0.011475 0 0.011475005 1 0.011476 1 0.011476005 0 0.011477 0 0.011477005 1 0.011478 1 0.011478005 0 0.011479 0 0.011479005 1 0.01148 1 0.011480005 0 0.011481 0 0.011481005 1 0.011482 1 0.011482005 0 0.011483 0 0.011483005 1 0.011484 1 0.011484005 0 0.011485 0 0.011485005 1 0.011486 1 0.011486005 0 0.011487 0 0.011487005 1 0.011488 1 0.011488005 0 0.012701 0 0.012701005 1 0.012702 1 0.012702005 0 0.012703 0 0.012703005 1 0.012704 1 0.012704005 0 0.012705 0 0.012705005 1 0.012706 1 0.012706005 0 0.012707 0 0.012707005 1 0.012708 1 0.012708005 0 0.012709 0 0.012709005 1 0.01271 1 0.012710005 0 0.012711 0 0.012711005 1 0.012712 1 0.012712005 0 0.012713 0 0.012713005 1 0.012714 1 0.012714005 0 0.012715 0 0.012715005 1 0.012716 1 0.012716005 0 0.012717 0 0.012717005 1 0.012718 1 0.012718005 0 0.012719 0 0.012719005 1 0.01272 1 0.012720005 0 0.012721 0 0.012721005 1 0.012722 1 0.012722005 0 0.012723 0 0.012723005 1 0.012724 1 0.012724005 0 0.012725 0 0.012725005 1 0.012726 1 0.012726005 0 0.012727 0 0.012727005 1 0.012728 1 0.012728005 0 0.012729 0 0.012729005 1 0.01273 1 0.012730005 0 0.012731 0 0.012731005 1 0.012732 1 0.012732005 0 0.012733 0 0.012733005 1 0.012734 1 0.012734005 0 0.012735 0 0.012735005 1 0.012736 1 0.012736005 0 0.012737 0 0.012737005 1 0.012738 1 0.012738005 0 0.013951 0 0.013951005 1 0.013952 1 0.013952005 0 0.013953 0 0.013953005 1 0.013954 1 0.013954005 0 0.013955 0 0.013955005 1 0.013956 1 0.013956005 0 0.013957 0 0.013957005 1 0.013958 1 0.013958005 0 0.013959 0 0.013959005 1 0.01396 1 0.013960005 0 0.013961 0 0.013961005 1 0.013962 1 0.013962005 0 0.013963 0 0.013963005 1 0.013964 1 0.013964005 0 0.013965 0 0.013965005 1 0.013966 1 0.013966005 0 0.013967 0 0.013967005 1 0.013968 1 0.013968005 0 0.013969 0 0.013969005 1 0.01397 1 0.013970005 0 0.013971 0 0.013971005 1 0.013972 1 0.013972005 0 0.013973 0 0.013973005 1 0.013974 1 0.013974005 0 0.013975 0 0.013975005 1 0.013976 1 0.013976005 0 0.013977 0 0.013977005 1 0.013978 1 0.013978005 0 0.013979 0 0.013979005 1 0.01398 1 0.013980005 0 0.013981 0 0.013981005 1 0.013982 1 0.013982005 0 0.013983 0 0.013983005 1 0.013984 1 0.013984005 0 0.013985 0 0.013985005 1 0.013986 1 0.013986005 0 0.013987 0 0.013987005 1 0.013988 1 0.013988005 0 0.015201 0 0.015201005 1 0.015202 1 0.015202005 0 0.015203 0 0.015203005 1 0.015204 1 0.015204005 0 0.015205 0 0.015205005 1 0.015206 1 0.015206005 0 0.015207 0 0.015207005 1 0.015208 1 0.015208005 0 0.015209 0 0.015209005 1 0.01521 1 0.015210005 0 0.015211 0 0.015211005 1 0.015212 1 0.015212005 0 0.015213 0 0.015213005 1 0.015214 1 0.015214005 0 0.015215 0 0.015215005 1 0.015216 1 0.015216005 0 0.015217 0 0.015217005 1 0.015218 1 0.015218005 0 0.015219 0 0.015219005 1 0.01522 1 0.015220005 0 0.015221 0 0.015221005 1 0.015222 1 0.015222005 0 0.015223 0 0.015223005 1 0.015224 1 0.015224005 0 0.015225 0 0.015225005 1 0.015226 1 0.015226005 0 0.015227 0 0.015227005 1 0.015228 1 0.015228005 0 0.015229 0 0.015229005 1 0.01523 1 0.015230005 0 0.015231 0 0.015231005 1 0.015232 1 0.015232005 0 0.015233 0 0.015233005 1 0.015234 1 0.015234005 0 0.015235 0 0.015235005 1 0.015236 1 0.015236005 0 0.015237 0 0.015237005 1 0.015238 1 0.015238005 0 0.016451 0 0.016451005 1 0.016452 1 0.016452005 0 0.016453 0 0.016453005 1 0.016454 1 0.016454005 0 0.016455 0 0.016455005 1 0.016456 1 0.016456005 0 0.016457 0 0.016457005 1 0.016458 1 0.016458005 0 0.016459 0 0.016459005 1 0.01646 1 0.016460005 0 0.016461 0 0.016461005 1 0.016462 1 0.016462005 0 0.016463 0 0.016463005 1 0.016464 1 0.016464005 0 0.016465 0 0.016465005 1 0.016466 1 0.016466005 0 0.016467 0 0.016467005 1 0.016468 1 0.016468005 0 0.016469 0 0.016469005 1 0.01647 1 0.016470005 0 0.016471 0 0.016471005 1 0.016472 1 0.016472005 0 0.016473 0 0.016473005 1 0.016474 1 0.016474005 0 0.016475 0 0.016475005 1 0.016476 1 0.016476005 0 0.016477 0 0.016477005 1 0.016478 1 0.016478005 0 0.016479 0 0.016479005 1 0.01648 1 0.016480005 0 0.016481 0 0.016481005 1 0.016482 1 0.016482005 0 0.016483 0 0.016483005 1 0.016484 1 0.016484005 0 0.016485 0 0.016485005 1 0.016486 1 0.016486005 0 0.016487 0 0.016487005 1 0.016488 1 0.016488005 0 0.017701 0 0.017701005 1 0.017702 1 0.017702005 0 0.017703 0 0.017703005 1 0.017704 1 0.017704005 0 0.017705 0 0.017705005 1 0.017706 1 0.017706005 0 0.017707 0 0.017707005 1 0.017708 1 0.017708005 0 0.017709 0 0.017709005 1 0.01771 1 0.017710005 0 0.017711 0 0.017711005 1 0.017712 1 0.017712005 0 0.017713 0 0.017713005 1 0.017714 1 0.017714005 0 0.017715 0 0.017715005 1 0.017716 1 0.017716005 0 0.017717 0 0.017717005 1 0.017718 1 0.017718005 0 0.017719 0 0.017719005 1 0.01772 1 0.017720005 0 0.017721 0 0.017721005 1 0.017722 1 0.017722005 0 0.017723 0 0.017723005 1 0.017724 1 0.017724005 0 0.017725 0 0.017725005 1 0.017726 1 0.017726005 0 0.017727 0 0.017727005 1 0.017728 1 0.017728005 0 0.017729 0 0.017729005 1 0.01773 1 0.017730005 0 0.017731 0 0.017731005 1 0.017732 1 0.017732005 0 0.017733 0 0.017733005 1 0.017734 1 0.017734005 0 0.017735 0 0.017735005 1 0.017736 1 0.017736005 0 0.017737 0 0.017737005 1 0.017738 1 0.017738005 0 0.018951 0 0.018951005 1 0.018952 1 0.018952005 0 0.018953 0 0.018953005 1 0.018954 1 0.018954005 0 0.018955 0 0.018955005 1 0.018956 1 0.018956005 0 0.018957 0 0.018957005 1 0.018958 1 0.018958005 0 0.018959 0 0.018959005 1 0.01896 1 0.018960005 0 0.018961 0 0.018961005 1 0.018962 1 0.018962005 0 0.018963 0 0.018963005 1 0.018964 1 0.018964005 0 0.018965 0 0.018965005 1 0.018966 1 0.018966005 0 0.018967 0 0.018967005 1 0.018968 1 0.018968005 0 0.018969 0 0.018969005 1 0.01897 1 0.018970005 0 0.018971 0 0.018971005 1 0.018972 1 0.018972005 0 0.018973 0 0.018973005 1 0.018974 1 0.018974005 0 0.018975 0 0.018975005 1 0.018976 1 0.018976005 0 0.018977 0 0.018977005 1 0.018978 1 0.018978005 0 0.018979 0 0.018979005 1 0.01898 1 0.018980005 0 0.018981 0 0.018981005 1 0.018982 1 0.018982005 0 0.018983 0 0.018983005 1 0.018984 1 0.018984005 0 0.018985 0 0.018985005 1 0.018986 1 0.018986005 0 0.018987 0 0.018987005 1 0.018988 1 0.018988005 0 0.020201 0 0.020201005 1 0.020202 1 0.020202005 0 0.020203 0 0.020203005 1 0.020204 1 0.020204005 0 0.020205 0 0.020205005 1 0.020206 1 0.020206005 0 0.020207 0 0.020207005 1 0.020208 1 0.020208005 0 0.020209 0 0.020209005 1 0.02021 1 0.020210005 0 0.020211 0 0.020211005 1 0.020212 1 0.020212005 0 0.020213 0 0.020213005 1 0.020214 1 0.020214005 0 0.020215 0 0.020215005 1 0.020216 1 0.020216005 0 0.020217 0 0.020217005 1 0.020218 1 0.020218005 0 0.020219 0 0.020219005 1 0.02022 1 0.020220005 0 0.020221 0 0.020221005 1 0.020222 1 0.020222005 0 0.020223 0 0.020223005 1 0.020224 1 0.020224005 0 0.020225 0 0.020225005 1 0.020226 1 0.020226005 0 0.020227 0 0.020227005 1 0.020228 1 0.020228005 0 0.020229 0 0.020229005 1 0.02023 1 0.020230005 0 0.020231 0 0.020231005 1 0.020232 1 0.020232005 0 0.020233 0 0.020233005 1 0.020234 1 0.020234005 0 0.020235 0 0.020235005 1 0.020236 1 0.020236005 0 0.020237 0 0.020237005 1 0.020238 1 0.020238005 0 0.021451 0 0.021451005 1 0.021452 1 0.021452005 0 0.021453 0 0.021453005 1 0.021454 1 0.021454005 0 0.021455 0 0.021455005 1 0.021456 1 0.021456005 0 0.021457 0 0.021457005 1 0.021458 1 0.021458005 0 0.021459 0 0.021459005 1 0.02146 1 0.021460005 0 0.021461 0 0.021461005 1 0.021462 1 0.021462005 0 0.021463 0 0.021463005 1 0.021464 1 0.021464005 0 0.021465 0 0.021465005 1 0.021466 1 0.021466005 0 0.021467 0 0.021467005 1 0.021468 1 0.021468005 0 0.021469 0 0.021469005 1 0.02147 1 0.021470005 0 0.021471 0 0.021471005 1 0.021472 1 0.021472005 0 0.021473 0 0.021473005 1 0.021474 1 0.021474005 0 0.021475 0 0.021475005 1 0.021476 1 0.021476005 0 0.021477 0 0.021477005 1 0.021478 1 0.021478005 0 0.021479 0 0.021479005 1 0.02148 1 0.021480005 0 0.021481 0 0.021481005 1 0.021482 1 0.021482005 0 0.021483 0 0.021483005 1 0.021484 1 0.021484005 0 0.021485 0 0.021485005 1 0.021486 1 0.021486005 0 0.021487 0 0.021487005 1 0.021488 1 0.021488005 0 0.022701 0 0.022701005 1 0.022702 1 0.022702005 0 0.022703 0 0.022703005 1 0.022704 1 0.022704005 0 0.022705 0 0.022705005 1 0.022706 1 0.022706005 0 0.022707 0 0.022707005 1 0.022708 1 0.022708005 0 0.022709 0 0.022709005 1 0.02271 1 0.022710005 0 0.022711 0 0.022711005 1 0.022712 1 0.022712005 0 0.022713 0 0.022713005 1 0.022714 1 0.022714005 0 0.022715 0 0.022715005 1 0.022716 1 0.022716005 0 0.022717 0 0.022717005 1 0.022718 1 0.022718005 0 0.022719 0 0.022719005 1 0.02272 1 0.022720005 0 0.022721 0 0.022721005 1 0.022722 1 0.022722005 0 0.022723 0 0.022723005 1 0.022724 1 0.022724005 0 0.022725 0 0.022725005 1 0.022726 1 0.022726005 0 0.022727 0 0.022727005 1 0.022728 1 0.022728005 0 0.022729 0 0.022729005 1 0.02273 1 0.022730005 0 0.022731 0 0.022731005 1 0.022732 1 0.022732005 0 0.022733 0 0.022733005 1 0.022734 1 0.022734005 0 0.022735 0 0.022735005 1 0.022736 1 0.022736005 0 0.022737 0 0.022737005 1 0.022738 1 0.022738005 0 0.023951 0 0.023951005 1 0.023952 1 0.023952005 0 0.023953 0 0.023953005 1 0.023954 1 0.023954005 0 0.023955 0 0.023955005 1 0.023956 1 0.023956005 0 0.023957 0 0.023957005 1 0.023958 1 0.023958005 0 0.023959 0 0.023959005 1 0.02396 1 0.023960005 0 0.023961 0 0.023961005 1 0.023962 1 0.023962005 0 0.023963 0 0.023963005 1 0.023964 1 0.023964005 0 0.023965 0 0.023965005 1 0.023966 1 0.023966005 0 0.023967 0 0.023967005 1 0.023968 1 0.023968005 0 0.023969 0 0.023969005 1 0.02397 1 0.023970005 0 0.023971 0 0.023971005 1 0.023972 1 0.023972005 0 0.023973 0 0.023973005 1 0.023974 1 0.023974005 0 0.023975 0 0.023975005 1 0.023976 1 0.023976005 0 0.023977 0 0.023977005 1 0.023978 1 0.023978005 0 0.023979 0 0.023979005 1 0.02398 1 0.023980005 0 0.023981 0 0.023981005 1 0.023982 1 0.023982005 0 0.023983 0 0.023983005 1 0.023984 1 0.023984005 0 0.023985 0 0.023985005 1 0.023986 1 0.023986005 0 0.023987 0 0.023987005 1 0.023988 1 0.023988005 0 0.025201 0 0.025201005 1 0.025202 1 0.025202005 0 0.025203 0 0.025203005 1 0.025204 1 0.025204005 0 0.025205 0 0.025205005 1 0.025206 1 0.025206005 0 0.025207 0 0.025207005 1 0.025208 1 0.025208005 0 0.025209 0 0.025209005 1 0.02521 1 0.025210005 0 0.025211 0 0.025211005 1 0.025212 1 0.025212005 0 0.025213 0 0.025213005 1 0.025214 1 0.025214005 0 0.025215 0 0.025215005 1 0.025216 1 0.025216005 0 0.025217 0 0.025217005 1 0.025218 1 0.025218005 0 0.025219 0 0.025219005 1 0.02522 1 0.025220005 0 0.025221 0 0.025221005 1 0.025222 1 0.025222005 0 0.025223 0 0.025223005 1 0.025224 1 0.025224005 0 0.025225 0 0.025225005 1 0.025226 1 0.025226005 0 0.025227 0 0.025227005 1 0.025228 1 0.025228005 0 0.025229 0 0.025229005 1 0.02523 1 0.025230005 0 0.025231 0 0.025231005 1 0.025232 1 0.025232005 0 0.025233 0 0.025233005 1 0.025234 1 0.025234005 0 0.025235 0 0.025235005 1 0.025236 1 0.025236005 0 0.025237 0 0.025237005 1 0.025238 1 0.025238005 0 0.026451 0 0.026451005 1 0.026452 1 0.026452005 0 0.026453 0 0.026453005 1 0.026454 1 0.026454005 0 0.026455 0 0.026455005 1 0.026456 1 0.026456005 0 0.026457 0 0.026457005 1 0.026458 1 0.026458005 0 0.026459 0 0.026459005 1 0.02646 1 0.026460005 0 0.026461 0 0.026461005 1 0.026462 1 0.026462005 0 0.026463 0 0.026463005 1 0.026464 1 0.026464005 0 0.026465 0 0.026465005 1 0.026466 1 0.026466005 0 0.026467 0 0.026467005 1 0.026468 1 0.026468005 0 0.026469 0 0.026469005 1 0.02647 1 0.026470005 0 0.026471 0 0.026471005 1 0.026472 1 0.026472005 0 0.026473 0 0.026473005 1 0.026474 1 0.026474005 0 0.026475 0 0.026475005 1 0.026476 1 0.026476005 0 0.026477 0 0.026477005 1 0.026478 1 0.026478005 0 0.026479 0 0.026479005 1 0.02648 1 0.026480005 0 0.026481 0 0.026481005 1 0.026482 1 0.026482005 0 0.026483 0 0.026483005 1 0.026484 1 0.026484005 0 0.026485 0 0.026485005 1 0.026486 1 0.026486005 0 0.026487 0 0.026487005 1 0.026488 1 0.026488005 0 0.027701 0 0.027701005 1 0.027702 1 0.027702005 0 0.027703 0 0.027703005 1 0.027704 1 0.027704005 0 0.027705 0 0.027705005 1 0.027706 1 0.027706005 0 0.027707 0 0.027707005 1 0.027708 1 0.027708005 0 0.027709 0 0.027709005 1 0.02771 1 0.027710005 0 0.027711 0 0.027711005 1 0.027712 1 0.027712005 0 0.027713 0 0.027713005 1 0.027714 1 0.027714005 0 0.027715 0 0.027715005 1 0.027716 1 0.027716005 0 0.027717 0 0.027717005 1 0.027718 1 0.027718005 0 0.027719 0 0.027719005 1 0.02772 1 0.027720005 0 0.027721 0 0.027721005 1 0.027722 1 0.027722005 0 0.027723 0 0.027723005 1 0.027724 1 0.027724005 0 0.027725 0 0.027725005 1 0.027726 1 0.027726005 0 0.027727 0 0.027727005 1 0.027728 1 0.027728005 0 0.027729 0 0.027729005 1 0.02773 1 0.027730005 0 0.027731 0 0.027731005 1 0.027732 1 0.027732005 0 0.027733 0 0.027733005 1 0.027734 1 0.027734005 0 0.027735 0 0.027735005 1 0.027736 1 0.027736005 0 0.027737 0 0.027737005 1 0.027738 1 0.027738005 0 0.028951 0 0.028951005 1 0.028952 1 0.028952005 0 0.028953 0 0.028953005 1 0.028954 1 0.028954005 0 0.028955 0 0.028955005 1 0.028956 1 0.028956005 0 0.028957 0 0.028957005 1 0.028958 1 0.028958005 0 0.028959 0 0.028959005 1 0.02896 1 0.028960005 0 0.028961 0 0.028961005 1 0.028962 1 0.028962005 0 0.028963 0 0.028963005 1 0.028964 1 0.028964005 0 0.028965 0 0.028965005 1 0.028966 1 0.028966005 0 0.028967 0 0.028967005 1 0.028968 1 0.028968005 0 0.028969 0 0.028969005 1 0.02897 1 0.028970005 0 0.028971 0 0.028971005 1 0.028972 1 0.028972005 0 0.028973 0 0.028973005 1 0.028974 1 0.028974005 0 0.028975 0 0.028975005 1 0.028976 1 0.028976005 0 0.028977 0 0.028977005 1 0.028978 1 0.028978005 0 0.028979 0 0.028979005 1 0.02898 1 0.028980005 0 0.028981 0 0.028981005 1 0.028982 1 0.028982005 0 0.028983 0 0.028983005 1 0.028984 1 0.028984005 0 0.028985 0 0.028985005 1 0.028986 1 0.028986005 0 0.028987 0 0.028987005 1 0.028988 1 0.028988005 0 0.030201 0 0.030201005 1 0.030202 1 0.030202005 0 0.030203 0 0.030203005 1 0.030204 1 0.030204005 0 0.030205 0 0.030205005 1 0.030206 1 0.030206005 0 0.030207 0 0.030207005 1 0.030208 1 0.030208005 0 0.030209 0 0.030209005 1 0.03021 1 0.030210005 0 0.030211 0 0.030211005 1 0.030212 1 0.030212005 0 0.030213 0 0.030213005 1 0.030214 1 0.030214005 0 0.030215 0 0.030215005 1 0.030216 1 0.030216005 0 0.030217 0 0.030217005 1 0.030218 1 0.030218005 0 0.030219 0 0.030219005 1 0.03022 1 0.030220005 0 0.030221 0 0.030221005 1 0.030222 1 0.030222005 0 0.030223 0 0.030223005 1 0.030224 1 0.030224005 0 0.030225 0 0.030225005 1 0.030226 1 0.030226005 0 0.030227 0 0.030227005 1 0.030228 1 0.030228005 0 0.030229 0 0.030229005 1 0.03023 1 0.030230005 0 0.030231 0 0.030231005 1 0.030232 1 0.030232005 0 0.030233 0 0.030233005 1 0.030234 1 0.030234005 0 0.030235 0 0.030235005 1 0.030236 1 0.030236005 0 0.030237 0 0.030237005 1 0.030238 1 0.030238005 0 0.031451 0 0.031451005 1 0.031452 1 0.031452005 0 0.031453 0 0.031453005 1 0.031454 1 0.031454005 0 0.031455 0 0.031455005 1 0.031456 1 0.031456005 0 0.031457 0 0.031457005 1 0.031458 1 0.031458005 0 0.031459 0 0.031459005 1 0.03146 1 0.031460005 0 0.031461 0 0.031461005 1 0.031462 1 0.031462005 0 0.031463 0 0.031463005 1 0.031464 1 0.031464005 0 0.031465 0 0.031465005 1 0.031466 1 0.031466005 0 0.031467 0 0.031467005 1 0.031468 1 0.031468005 0 0.031469 0 0.031469005 1 0.03147 1 0.031470005 0 0.031471 0 0.031471005 1 0.031472 1 0.031472005 0 0.031473 0 0.031473005 1 0.031474 1 0.031474005 0 0.031475 0 0.031475005 1 0.031476 1 0.031476005 0 0.031477 0 0.031477005 1 0.031478 1 0.031478005 0 0.031479 0 0.031479005 1 0.03148 1 0.031480005 0 0.031481 0 0.031481005 1 0.031482 1 0.031482005 0 0.031483 0 0.031483005 1 0.031484 1 0.031484005 0 0.031485 0 0.031485005 1 0.031486 1 0.031486005 0 0.031487 0 0.031487005 1 0.031488 1 0.031488005 0 0.032701 0 0.032701005 1 0.032702 1 0.032702005 0 0.032703 0 0.032703005 1 0.032704 1 0.032704005 0 0.032705 0 0.032705005 1 0.032706 1 0.032706005 0 0.032707 0 0.032707005 1 0.032708 1 0.032708005 0 0.032709 0 0.032709005 1 0.03271 1 0.032710005 0 0.032711 0 0.032711005 1 0.032712 1 0.032712005 0 0.032713 0 0.032713005 1 0.032714 1 0.032714005 0 0.032715 0 0.032715005 1 0.032716 1 0.032716005 0 0.032717 0 0.032717005 1 0.032718 1 0.032718005 0 0.032719 0 0.032719005 1 0.03272 1 0.032720005 0 0.032721 0 0.032721005 1 0.032722 1 0.032722005 0 0.032723 0 0.032723005 1 0.032724 1 0.032724005 0 0.032725 0 0.032725005 1 0.032726 1 0.032726005 0 0.032727 0 0.032727005 1 0.032728 1 0.032728005 0 0.032729 0 0.032729005 1 0.03273 1 0.032730005 0 0.032731 0 0.032731005 1 0.032732 1 0.032732005 0 0.032733 0 0.032733005 1 0.032734 1 0.032734005 0 0.032735 0 0.032735005 1 0.032736 1 0.032736005 0 0.032737 0 0.032737005 1 0.032738 1 0.032738005 0 0.033951 0 0.033951005 1 0.033952 1 0.033952005 0 0.033953 0 0.033953005 1 0.033954 1 0.033954005 0 0.033955 0 0.033955005 1 0.033956 1 0.033956005 0 0.033957 0 0.033957005 1 0.033958 1 0.033958005 0 0.033959 0 0.033959005 1 0.03396 1 0.033960005 0 0.033961 0 0.033961005 1 0.033962 1 0.033962005 0 0.033963 0 0.033963005 1 0.033964 1 0.033964005 0 0.033965 0 0.033965005 1 0.033966 1 0.033966005 0 0.033967 0 0.033967005 1 0.033968 1 0.033968005 0 0.033969 0 0.033969005 1 0.03397 1 0.033970005 0 0.033971 0 0.033971005 1 0.033972 1 0.033972005 0 0.033973 0 0.033973005 1 0.033974 1 0.033974005 0 0.033975 0 0.033975005 1 0.033976 1 0.033976005 0 0.033977 0 0.033977005 1 0.033978 1 0.033978005 0 0.033979 0 0.033979005 1 0.03398 1 0.033980005 0 0.033981 0 0.033981005 1 0.033982 1 0.033982005 0 0.033983 0 0.033983005 1 0.033984 1 0.033984005 0 0.033985 0 0.033985005 1 0.033986 1 0.033986005 0 0.033987 0 0.033987005 1 0.033988 1 0.033988005 0 0.035201 0 0.035201005 1 0.035202 1 0.035202005 0 0.035203 0 0.035203005 1 0.035204 1 0.035204005 0 0.035205 0 0.035205005 1 0.035206 1 0.035206005 0 0.035207 0 0.035207005 1 0.035208 1 0.035208005 0 0.035209 0 0.035209005 1 0.03521 1 0.035210005 0 0.035211 0 0.035211005 1 0.035212 1 0.035212005 0 0.035213 0 0.035213005 1 0.035214 1 0.035214005 0 0.035215 0 0.035215005 1 0.035216 1 0.035216005 0 0.035217 0 0.035217005 1 0.035218 1 0.035218005 0 0.035219 0 0.035219005 1 0.03522 1 0.035220005 0 0.035221 0 0.035221005 1 0.035222 1 0.035222005 0 0.035223 0 0.035223005 1 0.035224 1 0.035224005 0 0.035225 0 0.035225005 1 0.035226 1 0.035226005 0 0.035227 0 0.035227005 1 0.035228 1 0.035228005 0 0.035229 0 0.035229005 1 0.03523 1 0.035230005 0 0.035231 0 0.035231005 1 0.035232 1 0.035232005 0 0.035233 0 0.035233005 1 0.035234 1 0.035234005 0 0.035235 0 0.035235005 1 0.035236 1 0.035236005 0 0.035237 0 0.035237005 1 0.035238 1 0.035238005 0 0.036451 0 0.036451005 1 0.036452 1 0.036452005 0 0.036453 0 0.036453005 1 0.036454 1 0.036454005 0 0.036455 0 0.036455005 1 0.036456 1 0.036456005 0 0.036457 0 0.036457005 1 0.036458 1 0.036458005 0 0.036459 0 0.036459005 1 0.03646 1 0.036460005 0 0.036461 0 0.036461005 1 0.036462 1 0.036462005 0 0.036463 0 0.036463005 1 0.036464 1 0.036464005 0 0.036465 0 0.036465005 1 0.036466 1 0.036466005 0 0.036467 0 0.036467005 1 0.036468 1 0.036468005 0 0.036469 0 0.036469005 1 0.03647 1 0.036470005 0 0.036471 0 0.036471005 1 0.036472 1 0.036472005 0 0.036473 0 0.036473005 1 0.036474 1 0.036474005 0 0.036475 0 0.036475005 1 0.036476 1 0.036476005 0 0.036477 0 0.036477005 1 0.036478 1 0.036478005 0 0.036479 0 0.036479005 1 0.03648 1 0.036480005 0 0.036481 0 0.036481005 1 0.036482 1 0.036482005 0 0.036483 0 0.036483005 1 0.036484 1 0.036484005 0 0.036485 0 0.036485005 1 0.036486 1 0.036486005 0 0.036487 0 0.036487005 1 0.036488 1 0.036488005 0 0.037701 0 0.037701005 1 0.037702 1 0.037702005 0 0.037703 0 0.037703005 1 0.037704 1 0.037704005 0 0.037705 0 0.037705005 1 0.037706 1 0.037706005 0 0.037707 0 0.037707005 1 0.037708 1 0.037708005 0 0.037709 0 0.037709005 1 0.03771 1 0.037710005 0 0.037711 0 0.037711005 1 0.037712 1 0.037712005 0 0.037713 0 0.037713005 1 0.037714 1 0.037714005 0 0.037715 0 0.037715005 1 0.037716 1 0.037716005 0 0.037717 0 0.037717005 1 0.037718 1 0.037718005 0 0.037719 0 0.037719005 1 0.03772 1 0.037720005 0 0.037721 0 0.037721005 1 0.037722 1 0.037722005 0 0.037723 0 0.037723005 1 0.037724 1 0.037724005 0 0.037725 0 0.037725005 1 0.037726 1 0.037726005 0 0.037727 0 0.037727005 1 0.037728 1 0.037728005 0 0.037729 0 0.037729005 1 0.03773 1 0.037730005 0 0.037731 0 0.037731005 1 0.037732 1 0.037732005 0 0.037733 0 0.037733005 1 0.037734 1 0.037734005 0 0.037735 0 0.037735005 1 0.037736 1 0.037736005 0 0.037737 0 0.037737005 1 0.037738 1 0.037738005 0 0.038951 0 0.038951005 1 0.038952 1 0.038952005 0 0.038953 0 0.038953005 1 0.038954 1 0.038954005 0 0.038955 0 0.038955005 1 0.038956 1 0.038956005 0 0.038957 0 0.038957005 1 0.038958 1 0.038958005 0 0.038959 0 0.038959005 1 0.03896 1 0.038960005 0 0.038961 0 0.038961005 1 0.038962 1 0.038962005 0 0.038963 0 0.038963005 1 0.038964 1 0.038964005 0 0.038965 0 0.038965005 1 0.038966 1 0.038966005 0 0.038967 0 0.038967005 1 0.038968 1 0.038968005 0 0.038969 0 0.038969005 1 0.03897 1 0.038970005 0 0.038971 0 0.038971005 1 0.038972 1 0.038972005 0 0.038973 0 0.038973005 1 0.038974 1 0.038974005 0 0.038975 0 0.038975005 1 0.038976 1 0.038976005 0 0.038977 0 0.038977005 1 0.038978 1 0.038978005 0 0.038979 0 0.038979005 1 0.03898 1 0.038980005 0 0.038981 0 0.038981005 1 0.038982 1 0.038982005 0 0.038983 0 0.038983005 1 0.038984 1 0.038984005 0 0.038985 0 0.038985005 1 0.038986 1 0.038986005 0 0.038987 0 0.038987005 1 0.038988 1 0.038988005 0 0.040201 0 0.040201005 1 0.040202 1 0.040202005 0 0.040203 0 0.040203005 1 0.040204 1 0.040204005 0 0.040205 0 0.040205005 1 0.040206 1 0.040206005 0 0.040207 0 0.040207005 1 0.040208 1 0.040208005 0 0.040209 0 0.040209005 1 0.04021 1 0.040210005 0 0.040211 0 0.040211005 1 0.040212 1 0.040212005 0 0.040213 0 0.040213005 1 0.040214 1 0.040214005 0 0.040215 0 0.040215005 1 0.040216 1 0.040216005 0 0.040217 0 0.040217005 1 0.040218 1 0.040218005 0 0.040219 0 0.040219005 1 0.04022 1 0.040220005 0 0.040221 0 0.040221005 1 0.040222 1 0.040222005 0 0.040223 0 0.040223005 1 0.040224 1 0.040224005 0 0.040225 0 0.040225005 1 0.040226 1 0.040226005 0 0.040227 0 0.040227005 1 0.040228 1 0.040228005 0 0.040229 0 0.040229005 1 0.04023 1 0.040230005 0 0.040231 0 0.040231005 1 0.040232 1 0.040232005 0 0.040233 0 0.040233005 1 0.040234 1 0.040234005 0 0.040235 0 0.040235005 1 0.040236 1 0.040236005 0 0.040237 0 0.040237005 1 0.040238 1 0.040238005 0 0.041451 0 0.041451005 1 0.041452 1 0.041452005 0 0.041453 0 0.041453005 1 0.041454 1 0.041454005 0 0.041455 0 0.041455005 1 0.041456 1 0.041456005 0 0.041457 0 0.041457005 1 0.041458 1 0.041458005 0 0.041459 0 0.041459005 1 0.04146 1 0.041460005 0 0.041461 0 0.041461005 1 0.041462 1 0.041462005 0 0.041463 0 0.041463005 1 0.041464 1 0.041464005 0 0.041465 0 0.041465005 1 0.041466 1 0.041466005 0 0.041467 0 0.041467005 1 0.041468 1 0.041468005 0 0.041469 0 0.041469005 1 0.04147 1 0.041470005 0 0.041471 0 0.041471005 1 0.041472 1 0.041472005 0 0.041473 0 0.041473005 1 0.041474 1 0.041474005 0 0.041475 0 0.041475005 1 0.041476 1 0.041476005 0 0.041477 0 0.041477005 1 0.041478 1 0.041478005 0 0.041479 0 0.041479005 1 0.04148 1 0.041480005 0 0.041481 0 0.041481005 1 0.041482 1 0.041482005 0 0.041483 0 0.041483005 1 0.041484 1 0.041484005 0 0.041485 0 0.041485005 1 0.041486 1 0.041486005 0 0.041487 0 0.041487005 1 0.041488 1 0.041488005 0 0.042701 0 0.042701005 1 0.042702 1 0.042702005 0 0.042703 0 0.042703005 1 0.042704 1 0.042704005 0 0.042705 0 0.042705005 1 0.042706 1 0.042706005 0 0.042707 0 0.042707005 1 0.042708 1 0.042708005 0 0.042709 0 0.042709005 1 0.04271 1 0.042710005 0 0.042711 0 0.042711005 1 0.042712 1 0.042712005 0 0.042713 0 0.042713005 1 0.042714 1 0.042714005 0 0.042715 0 0.042715005 1 0.042716 1 0.042716005 0 0.042717 0 0.042717005 1 0.042718 1 0.042718005 0 0.042719 0 0.042719005 1 0.04272 1 0.042720005 0 0.042721 0 0.042721005 1 0.042722 1 0.042722005 0 0.042723 0 0.042723005 1 0.042724 1 0.042724005 0 0.042725 0 0.042725005 1 0.042726 1 0.042726005 0 0.042727 0 0.042727005 1 0.042728 1 0.042728005 0 0.042729 0 0.042729005 1 0.04273 1 0.042730005 0 0.042731 0 0.042731005 1 0.042732 1 0.042732005 0 0.042733 0 0.042733005 1 0.042734 1 0.042734005 0 0.042735 0 0.042735005 1 0.042736 1 0.042736005 0 0.042737 0 0.042737005 1 0.042738 1 0.042738005 0 0.043951 0 0.043951005 1 0.043952 1 0.043952005 0 0.043953 0 0.043953005 1 0.043954 1 0.043954005 0 0.043955 0 0.043955005 1 0.043956 1 0.043956005 0 0.043957 0 0.043957005 1 0.043958 1 0.043958005 0 0.043959 0 0.043959005 1 0.04396 1 0.043960005 0 0.043961 0 0.043961005 1 0.043962 1 0.043962005 0 0.043963 0 0.043963005 1 0.043964 1 0.043964005 0 0.043965 0 0.043965005 1 0.043966 1 0.043966005 0 0.043967 0 0.043967005 1 0.043968 1 0.043968005 0 0.043969 0 0.043969005 1 0.04397 1 0.043970005 0 0.043971 0 0.043971005 1 0.043972 1 0.043972005 0 0.043973 0 0.043973005 1 0.043974 1 0.043974005 0 0.043975 0 0.043975005 1 0.043976 1 0.043976005 0 0.043977 0 0.043977005 1 0.043978 1 0.043978005 0 0.043979 0 0.043979005 1 0.04398 1 0.043980005 0 0.043981 0 0.043981005 1 0.043982 1 0.043982005 0 0.043983 0 0.043983005 1 0.043984 1 0.043984005 0 0.043985 0 0.043985005 1 0.043986 1 0.043986005 0 0.043987 0 0.043987005 1 0.043988 1 0.043988005 0 0.045201 0 0.045201005 1 0.045202 1 0.045202005 0 0.045203 0 0.045203005 1 0.045204 1 0.045204005 0 0.045205 0 0.045205005 1 0.045206 1 0.045206005 0 0.045207 0 0.045207005 1 0.045208 1 0.045208005 0 0.045209 0 0.045209005 1 0.04521 1 0.045210005 0 0.045211 0 0.045211005 1 0.045212 1 0.045212005 0 0.045213 0 0.045213005 1 0.045214 1 0.045214005 0 0.045215 0 0.045215005 1 0.045216 1 0.045216005 0 0.045217 0 0.045217005 1 0.045218 1 0.045218005 0 0.045219 0 0.045219005 1 0.04522 1 0.045220005 0 0.045221 0 0.045221005 1 0.045222 1 0.045222005 0 0.045223 0 0.045223005 1 0.045224 1 0.045224005 0 0.045225 0 0.045225005 1 0.045226 1 0.045226005 0 0.045227 0 0.045227005 1 0.045228 1 0.045228005 0 0.045229 0 0.045229005 1 0.04523 1 0.045230005 0 0.045231 0 0.045231005 1 0.045232 1 0.045232005 0 0.045233 0 0.045233005 1 0.045234 1 0.045234005 0 0.045235 0 0.045235005 1 0.045236 1 0.045236005 0 0.045237 0 0.045237005 1 0.045238 1 0.045238005 0 0.046451 0 0.046451005 1 0.046452 1 0.046452005 0 0.046453 0 0.046453005 1 0.046454 1 0.046454005 0 0.046455 0 0.046455005 1 0.046456 1 0.046456005 0 0.046457 0 0.046457005 1 0.046458 1 0.046458005 0 0.046459 0 0.046459005 1 0.04646 1 0.046460005 0 0.046461 0 0.046461005 1 0.046462 1 0.046462005 0 0.046463 0 0.046463005 1 0.046464 1 0.046464005 0 0.046465 0 0.046465005 1 0.046466 1 0.046466005 0 0.046467 0 0.046467005 1 0.046468 1 0.046468005 0 0.046469 0 0.046469005 1 0.04647 1 0.046470005 0 0.046471 0 0.046471005 1 0.046472 1 0.046472005 0 0.046473 0 0.046473005 1 0.046474 1 0.046474005 0 0.046475 0 0.046475005 1 0.046476 1 0.046476005 0 0.046477 0 0.046477005 1 0.046478 1 0.046478005 0 0.046479 0 0.046479005 1 0.04648 1 0.046480005 0 0.046481 0 0.046481005 1 0.046482 1 0.046482005 0 0.046483 0 0.046483005 1 0.046484 1 0.046484005 0 0.046485 0 0.046485005 1 0.046486 1 0.046486005 0 0.046487 0 0.046487005 1 0.046488 1 0.046488005 0 0.047701 0 0.047701005 1 0.047702 1 0.047702005 0 0.047703 0 0.047703005 1 0.047704 1 0.047704005 0 0.047705 0 0.047705005 1 0.047706 1 0.047706005 0 0.047707 0 0.047707005 1 0.047708 1 0.047708005 0 0.047709 0 0.047709005 1 0.04771 1 0.047710005 0 0.047711 0 0.047711005 1 0.047712 1 0.047712005 0 0.047713 0 0.047713005 1 0.047714 1 0.047714005 0 0.047715 0 0.047715005 1 0.047716 1 0.047716005 0 0.047717 0 0.047717005 1 0.047718 1 0.047718005 0 0.047719 0 0.047719005 1 0.04772 1 0.047720005 0 0.047721 0 0.047721005 1 0.047722 1 0.047722005 0 0.047723 0 0.047723005 1 0.047724 1 0.047724005 0 0.047725 0 0.047725005 1 0.047726 1 0.047726005 0 0.047727 0 0.047727005 1 0.047728 1 0.047728005 0 0.047729 0 0.047729005 1 0.04773 1 0.047730005 0 0.047731 0 0.047731005 1 0.047732 1 0.047732005 0 0.047733 0 0.047733005 1 0.047734 1 0.047734005 0 0.047735 0 0.047735005 1 0.047736 1 0.047736005 0 0.047737 0 0.047737005 1 0.047738 1 0.047738005 0 0.048951 0 0.048951005 1 0.048952 1 0.048952005 0 0.048953 0 0.048953005 1 0.048954 1 0.048954005 0 0.048955 0 0.048955005 1 0.048956 1 0.048956005 0 0.048957 0 0.048957005 1 0.048958 1 0.048958005 0 0.048959 0 0.048959005 1 0.04896 1 0.048960005 0 0.048961 0 0.048961005 1 0.048962 1 0.048962005 0 0.048963 0 0.048963005 1 0.048964 1 0.048964005 0 0.048965 0 0.048965005 1 0.048966 1 0.048966005 0 0.048967 0 0.048967005 1 0.048968 1 0.048968005 0 0.048969 0 0.048969005 1 0.04897 1 0.048970005 0 0.048971 0 0.048971005 1 0.048972 1 0.048972005 0 0.048973 0 0.048973005 1 0.048974 1 0.048974005 0 0.048975 0 0.048975005 1 0.048976 1 0.048976005 0 0.048977 0 0.048977005 1 0.048978 1 0.048978005 0 0.048979 0 0.048979005 1 0.04898 1 0.048980005 0 0.048981 0 0.048981005 1 0.048982 1 0.048982005 0 0.048983 0 0.048983005 1 0.048984 1 0.048984005 0 0.048985 0 0.048985005 1 0.048986 1 0.048986005 0 0.048987 0 0.048987005 1 0.048988 1 0.048988005 0)
Vgp15_ctl gp15_ctl 0 PWL(0 0 0.0002 0 0.000200005 1 0.000204 1 0.000204005 0 0.00145 0 0.001450005 1 0.001454 1 0.001454005 0 0.001458 0 0.001458005 1 0.00146 1 0.001460005 0 0.0027 0 0.002700005 1 0.002704 1 0.002704005 0 0.002706 0 0.002706005 1 0.002708 1 0.002708005 0 0.00395 0 0.003950005 1 0.003954 1 0.003954005 0 0.003956 0 0.003956005 1 0.00396 1 0.003960005 0 0.0052 0 0.005200005 1 0.005206 1 0.005206005 0 0.00645 0 0.006450005 1 0.006456 1 0.006456005 0 0.006458 0 0.006458005 1 0.00646 1 0.006460005 0 0.0077 0 0.007700005 1 0.007708 1 0.007708005 0 0.00895 0 0.008950005 1 0.00896 1 0.008960005 0 0.0102 0 0.010200005 1 0.010204 1 0.010204005 0 0.01145 0 0.011450005 1 0.011454 1 0.011454005 0 0.011458 0 0.011458005 1 0.01146 1 0.011460005 0 0.0127 0 0.012700005 1 0.012704 1 0.012704005 0 0.012706 0 0.012706005 1 0.012708 1 0.012708005 0 0.01395 0 0.013950005 1 0.013954 1 0.013954005 0 0.013956 0 0.013956005 1 0.01396 1 0.013960005 0 0.0152 0 0.015200005 1 0.015206 1 0.015206005 0 0.01645 0 0.016450005 1 0.016456 1 0.016456005 0 0.016458 0 0.016458005 1 0.01646 1 0.016460005 0 0.0177 0 0.017700005 1 0.017708 1 0.017708005 0 0.01895 0 0.018950005 1 0.01896 1 0.018960005 0 0.0202 0 0.020200005 1 0.020204 1 0.020204005 0 0.02145 0 0.021450005 1 0.021454 1 0.021454005 0 0.021458 0 0.021458005 1 0.02146 1 0.021460005 0 0.0227 0 0.022700005 1 0.022704 1 0.022704005 0 0.022706 0 0.022706005 1 0.022708 1 0.022708005 0 0.02395 0 0.023950005 1 0.023954 1 0.023954005 0 0.023956 0 0.023956005 1 0.02396 1 0.023960005 0 0.0252 0 0.025200005 1 0.025206 1 0.025206005 0 0.02645 0 0.026450005 1 0.026456 1 0.026456005 0 0.026458 0 0.026458005 1 0.02646 1 0.026460005 0 0.0277 0 0.027700005 1 0.027708 1 0.027708005 0 0.02895 0 0.028950005 1 0.02896 1 0.028960005 0 0.0302 0 0.030200005 1 0.030204 1 0.030204005 0 0.03145 0 0.031450005 1 0.031454 1 0.031454005 0 0.031458 0 0.031458005 1 0.03146 1 0.031460005 0 0.0327 0 0.032700005 1 0.032704 1 0.032704005 0 0.032706 0 0.032706005 1 0.032708 1 0.032708005 0 0.03395 0 0.033950005 1 0.033954 1 0.033954005 0 0.033956 0 0.033956005 1 0.03396 1 0.033960005 0 0.0352 0 0.035200005 1 0.035206 1 0.035206005 0 0.03645 0 0.036450005 1 0.036456 1 0.036456005 0 0.036458 0 0.036458005 1 0.03646 1 0.036460005 0 0.0377 0 0.037700005 1 0.037708 1 0.037708005 0 0.03895 0 0.038950005 1 0.03896 1 0.038960005 0 0.0402 0 0.040200005 1 0.040204 1 0.040204005 0 0.04145 0 0.041450005 1 0.041454 1 0.041454005 0 0.041458 0 0.041458005 1 0.04146 1 0.041460005 0 0.0427 0 0.042700005 1 0.042704 1 0.042704005 0 0.042706 0 0.042706005 1 0.042708 1 0.042708005 0 0.04395 0 0.043950005 1 0.043954 1 0.043954005 0 0.043956 0 0.043956005 1 0.04396 1 0.043960005 0 0.0452 0 0.045200005 1 0.045206 1 0.045206005 0 0.04645 0 0.046450005 1 0.046456 1 0.046456005 0 0.046458 0 0.046458005 1 0.04646 1 0.046460005 0 0.0477 0 0.047700005 1 0.047708 1 0.047708005 0 0.04895 0 0.048950005 1 0.04896 1 0.048960005 0)
Vgp13_oe gp13_oe 0 1
Vgp14_oe gp14_oe 0 1
Vgp15_oe gp15_oe 0 1
Vgp12_ctl gp12_ctl 0 0
Vgp12_oe gp12_oe 0 0
* tracks of the bus (assumption)
Ct1 c_sck 0 1e-11
Ct2 c_mosi 0 1e-11
Ct3 c_mon_cs 0 1e-11
.control
save ch0 ch1 ch2 ch3 ch4 ch5 ch6 ch7 c_sck c_mosi c_mon_cs gp14 xu40.samp
tran 20n 0.0501 0 20u
.endc
.end
