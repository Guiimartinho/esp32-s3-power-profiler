* Logic line D0: a source behind 1000 ohm stepped from -12 V to +12 V, array breakdown 7.5 V
.include "../../models/digital.lib"
RRN6_1 din0 0 100000
RRN6_2 din1 0 100000
RRN6_3 din2 0 100000
RRN6_4 din3 0 100000
RRN8_1 j_d0 b_d0 330
RRN8_2 j_d1 b_d1 330
RRN8_3 j_d2 b_d2 330
RRN8_4 j_d3 b_d3 330
XU36 j_d0 j_d1 j_d2 j_d3 0 DIGITAL_TPD4E1U06 vbr=7.5
XU38 v3c 0 din0 din1 din2 din3 din4 din5 din6 din7 0 0 0 b_d7 b_d6 b_d5 b_d4 b_d3 b_d2 b_d1 b_d0 0 vccb vccb DIGITAL_LVC8T245
C100 vccb 0 1e-07
C101 v3c 0 1e-07
RRN11_1 b_d0 0 470000
RRN11_2 b_d1 0 470000
RRN11_3 b_d2 0 470000
RRN11_4 b_d3 0 470000
* a source with its internal resistance at the connector pin of D0;
* the translator supplies as ideal sources, the other lines open
Vabuse src 0 0
Rsource src j_d0 1000
Vccb vccb 0 3.3
Vlogic v3c 0 3.3
.options gmin=1e-13
.control
dc Vabuse -12 12 0.05
.endc
.end
