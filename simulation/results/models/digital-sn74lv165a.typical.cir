* SN74LV165A: load, shift and delays into 15 pF
.include "../../models/digital.lib"
* supply 3.3 V, 15 pF at the output, generators with edges of 1 ns
Vcc vcc 0 3.3
X1 pl cp d4 d5 d6 d7 qn 0 q ds d0 d1 d2 d3 0 vcc DIGITAL_LV165A tclk=7.6e-09 tld=8e-09
Cq q 0 15p
Vpl pl 0 PWL(0 3.3 20n 3.3 21n 0 1e-07 0 1.01e-07 3.3)
Vcp cp 0 PULSE(0 3.3 1.5e-07 1n 1n 4.9e-08 1e-07)
Vds ds 0 3.3
* input D7 changes while the load pin is low: the output follows it
Vd7 d7 0 PWL(0 0 50n 0 51n 3.3)
Vd6 d6 0 0
Vd5 d5 0 3.3
Vd4 d4 0 3.3
Vd3 d3 0 0
Vd2 d2 0 0
Vd1 d1 0 3.3
Vd0 d0 0 0
.control
tran 0.05n 1.1u 0 0.5n
.endc
.end
