* MCP3208 inputs: nine frames, one per channel and channel 7 twice
.include "../../models/digital.lib"
* channels 0 to 6 at 0.3 V steps from stiff sources; channel 7 is a
* capacitor of 100 nF charged to 2.5 V with nothing to refill it
Vdd vdd 0 3.3
Vref vref 0 2.5
X1 ch0 ch1 ch2 ch3 ch4 ch5 ch6 ch7 0 cs din dout clk 0 vref vdd DIGITAL_MCP3208
Vch0 ch0 0 0.3
Vch1 ch1 0 0.6
Vch2 ch2 0 0.9
Vch3 ch3 0 1.2
Vch4 ch4 0 1.5
Vch5 ch5 0 1.8
Vch6 ch6 0 2.1
C7 ch7 0 1e-07 IC=2.5
R7 ch7 0 1e12
Vcs cs 0 PWL(0 3.3 2e-06 3.3 2.005e-06 0 2.15e-05 0 2.1505e-05 3.3 3.2e-05 3.3 3.2005e-05 0 5.15e-05 0 5.1505e-05 3.3 6.2e-05 3.3 6.2005e-05 0 8.15e-05 0 8.1505e-05 3.3 9.2e-05 3.3 9.2005e-05 0 0.0001115 0 0.000111505 3.3 0.000122 3.3 0.000122005 0 0.0001415 0 0.000141505 3.3 0.000152 3.3 0.000152005 0 0.0001715 0 0.000171505 3.3 0.000182 3.3 0.000182005 0 0.0002015 0 0.000201505 3.3 0.000212 3.3 0.000212005 0 0.0002315 0 0.000231505 3.3 0.000242 3.3 0.000242005 0 0.0002615 0 0.000261505 3.3)
Vclk clk 0 PWL(0 0 2.5e-06 0 2.505e-06 3.3 3e-06 3.3 3.005e-06 0 3.5e-06 0 3.505e-06 3.3 4e-06 3.3 4.005e-06 0 4.5e-06 0 4.505e-06 3.3 5e-06 3.3 5.005e-06 0 5.5e-06 0 5.505e-06 3.3 6e-06 3.3 6.005e-06 0 6.5e-06 0 6.505e-06 3.3 7e-06 3.3 7.005e-06 0 7.5e-06 0 7.505e-06 3.3 8e-06 3.3 8.005e-06 0 8.5e-06 0 8.505e-06 3.3 9e-06 3.3 9.005e-06 0 9.5e-06 0 9.505e-06 3.3 1e-05 3.3 1.0005e-05 0 1.05e-05 0 1.0505e-05 3.3 1.1e-05 3.3 1.1005e-05 0 1.15e-05 0 1.1505e-05 3.3 1.2e-05 3.3 1.2005e-05 0 1.25e-05 0 1.2505e-05 3.3 1.3e-05 3.3 1.3005e-05 0 1.35e-05 0 1.3505e-05 3.3 1.4e-05 3.3 1.4005e-05 0 1.45e-05 0 1.4505e-05 3.3 1.5e-05 3.3 1.5005e-05 0 1.55e-05 0 1.5505e-05 3.3 1.6e-05 3.3 1.6005e-05 0 1.65e-05 0 1.6505e-05 3.3 1.7e-05 3.3 1.7005e-05 0 1.75e-05 0 1.7505e-05 3.3 1.8e-05 3.3 1.8005e-05 0 1.85e-05 0 1.8505e-05 3.3 1.9e-05 3.3 1.9005e-05 0 1.95e-05 0 1.9505e-05 3.3 2e-05 3.3 2.0005e-05 0 2.05e-05 0 2.0505e-05 3.3 2.1e-05 3.3 2.1005e-05 0 3.25e-05 0 3.2505e-05 3.3 3.3e-05 3.3 3.3005e-05 0 3.35e-05 0 3.3505e-05 3.3 3.4e-05 3.3 3.4005e-05 0 3.45e-05 0 3.4505e-05 3.3 3.5e-05 3.3 3.5005e-05 0 3.55e-05 0 3.5505e-05 3.3 3.6e-05 3.3 3.6005e-05 0 3.65e-05 0 3.6505e-05 3.3 3.7e-05 3.3 3.7005e-05 0 3.75e-05 0 3.7505e-05 3.3 3.8e-05 3.3 3.8005e-05 0 3.85e-05 0 3.8505e-05 3.3 3.9e-05 3.3 3.9005e-05 0 3.95e-05 0 3.9505e-05 3.3 4e-05 3.3 4.0005e-05 0 4.05e-05 0 4.0505e-05 3.3 4.1e-05 3.3 4.1005e-05 0 4.15e-05 0 4.1505e-05 3.3 4.2e-05 3.3 4.2005e-05 0 4.25e-05 0 4.2505e-05 3.3 4.3e-05 3.3 4.3005e-05 0 4.35e-05 0 4.3505e-05 3.3 4.4e-05 3.3 4.4005e-05 0 4.45e-05 0 4.4505e-05 3.3 4.5e-05 3.3 4.5005e-05 0 4.55e-05 0 4.5505e-05 3.3 4.6e-05 3.3 4.6005e-05 0 4.65e-05 0 4.6505e-05 3.3 4.7e-05 3.3 4.7005e-05 0 4.75e-05 0 4.7505e-05 3.3 4.8e-05 3.3 4.8005e-05 0 4.85e-05 0 4.8505e-05 3.3 4.9e-05 3.3 4.9005e-05 0 4.95e-05 0 4.9505e-05 3.3 5e-05 3.3 5.0005e-05 0 5.05e-05 0 5.0505e-05 3.3 5.1e-05 3.3 5.1005e-05 0 6.25e-05 0 6.2505e-05 3.3 6.3e-05 3.3 6.3005e-05 0 6.35e-05 0 6.3505e-05 3.3 6.4e-05 3.3 6.4005e-05 0 6.45e-05 0 6.4505e-05 3.3 6.5e-05 3.3 6.5005e-05 0 6.55e-05 0 6.5505e-05 3.3 6.6e-05 3.3 6.6005e-05 0 6.65e-05 0 6.6505e-05 3.3 6.7e-05 3.3 6.7005e-05 0 6.75e-05 0 6.7505e-05 3.3 6.8e-05 3.3 6.8005e-05 0 6.85e-05 0 6.8505e-05 3.3 6.9e-05 3.3 6.9005e-05 0 6.95e-05 0 6.9505e-05 3.3 7e-05 3.3 7.0005e-05 0 7.05e-05 0 7.0505e-05 3.3 7.1e-05 3.3 7.1005e-05 0 7.15e-05 0 7.1505e-05 3.3 7.2e-05 3.3 7.2005e-05 0 7.25e-05 0 7.2505e-05 3.3 7.3e-05 3.3 7.3005e-05 0 7.35e-05 0 7.3505e-05 3.3 7.4e-05 3.3 7.4005e-05 0 7.45e-05 0 7.4505e-05 3.3 7.5e-05 3.3 7.5005e-05 0 7.55e-05 0 7.5505e-05 3.3 7.6e-05 3.3 7.6005e-05 0 7.65e-05 0 7.6505e-05 3.3 7.7e-05 3.3 7.7005e-05 0 7.75e-05 0 7.7505e-05 3.3 7.8e-05 3.3 7.8005e-05 0 7.85e-05 0 7.8505e-05 3.3 7.9e-05 3.3 7.9005e-05 0 7.95e-05 0 7.9505e-05 3.3 8e-05 3.3 8.0005e-05 0 8.05e-05 0 8.0505e-05 3.3 8.1e-05 3.3 8.1005e-05 0 9.25e-05 0 9.2505e-05 3.3 9.3e-05 3.3 9.3005e-05 0 9.35e-05 0 9.3505e-05 3.3 9.4e-05 3.3 9.4005e-05 0 9.45e-05 0 9.4505e-05 3.3 9.5e-05 3.3 9.5005e-05 0 9.55e-05 0 9.5505e-05 3.3 9.6e-05 3.3 9.6005e-05 0 9.65e-05 0 9.6505e-05 3.3 9.7e-05 3.3 9.7005e-05 0 9.75e-05 0 9.7505e-05 3.3 9.8e-05 3.3 9.8005e-05 0 9.85e-05 0 9.8505e-05 3.3 9.9e-05 3.3 9.9005e-05 0 9.95e-05 0 9.9505e-05 3.3 0.0001 3.3 0.000100005 0 0.0001005 0 0.000100505 3.3 0.000101 3.3 0.000101005 0 0.0001015 0 0.000101505 3.3 0.000102 3.3 0.000102005 0 0.0001025 0 0.000102505 3.3 0.000103 3.3 0.000103005 0 0.0001035 0 0.000103505 3.3 0.000104 3.3 0.000104005 0 0.0001045 0 0.000104505 3.3 0.000105 3.3 0.000105005 0 0.0001055 0 0.000105505 3.3 0.000106 3.3 0.000106005 0 0.0001065 0 0.000106505 3.3 0.000107 3.3 0.000107005 0 0.0001075 0 0.000107505 3.3 0.000108 3.3 0.000108005 0 0.0001085 0 0.000108505 3.3 0.000109 3.3 0.000109005 0 0.0001095 0 0.000109505 3.3 0.00011 3.3 0.000110005 0 0.0001105 0 0.000110505 3.3 0.000111 3.3 0.000111005 0 0.0001225 0 0.000122505 3.3 0.000123 3.3 0.000123005 0 0.0001235 0 0.000123505 3.3 0.000124 3.3 0.000124005 0 0.0001245 0 0.000124505 3.3 0.000125 3.3 0.000125005 0 0.0001255 0 0.000125505 3.3 0.000126 3.3 0.000126005 0 0.0001265 0 0.000126505 3.3 0.000127 3.3 0.000127005 0 0.0001275 0 0.000127505 3.3 0.000128 3.3 0.000128005 0 0.0001285 0 0.000128505 3.3 0.000129 3.3 0.000129005 0 0.0001295 0 0.000129505 3.3 0.00013 3.3 0.000130005 0 0.0001305 0 0.000130505 3.3 0.000131 3.3 0.000131005 0 0.0001315 0 0.000131505 3.3 0.000132 3.3 0.000132005 0 0.0001325 0 0.000132505 3.3 0.000133 3.3 0.000133005 0 0.0001335 0 0.000133505 3.3 0.000134 3.3 0.000134005 0 0.0001345 0 0.000134505 3.3 0.000135 3.3 0.000135005 0 0.0001355 0 0.000135505 3.3 0.000136 3.3 0.000136005 0 0.0001365 0 0.000136505 3.3 0.000137 3.3 0.000137005 0 0.0001375 0 0.000137505 3.3 0.000138 3.3 0.000138005 0 0.0001385 0 0.000138505 3.3 0.000139 3.3 0.000139005 0 0.0001395 0 0.000139505 3.3 0.00014 3.3 0.000140005 0 0.0001405 0 0.000140505 3.3 0.000141 3.3 0.000141005 0 0.0001525 0 0.000152505 3.3 0.000153 3.3 0.000153005 0 0.0001535 0 0.000153505 3.3 0.000154 3.3 0.000154005 0 0.0001545 0 0.000154505 3.3 0.000155 3.3 0.000155005 0 0.0001555 0 0.000155505 3.3 0.000156 3.3 0.000156005 0 0.0001565 0 0.000156505 3.3 0.000157 3.3 0.000157005 0 0.0001575 0 0.000157505 3.3 0.000158 3.3 0.000158005 0 0.0001585 0 0.000158505 3.3 0.000159 3.3 0.000159005 0 0.0001595 0 0.000159505 3.3 0.00016 3.3 0.000160005 0 0.0001605 0 0.000160505 3.3 0.000161 3.3 0.000161005 0 0.0001615 0 0.000161505 3.3 0.000162 3.3 0.000162005 0 0.0001625 0 0.000162505 3.3 0.000163 3.3 0.000163005 0 0.0001635 0 0.000163505 3.3 0.000164 3.3 0.000164005 0 0.0001645 0 0.000164505 3.3 0.000165 3.3 0.000165005 0 0.0001655 0 0.000165505 3.3 0.000166 3.3 0.000166005 0 0.0001665 0 0.000166505 3.3 0.000167 3.3 0.000167005 0 0.0001675 0 0.000167505 3.3 0.000168 3.3 0.000168005 0 0.0001685 0 0.000168505 3.3 0.000169 3.3 0.000169005 0 0.0001695 0 0.000169505 3.3 0.00017 3.3 0.000170005 0 0.0001705 0 0.000170505 3.3 0.000171 3.3 0.000171005 0 0.0001825 0 0.000182505 3.3 0.000183 3.3 0.000183005 0 0.0001835 0 0.000183505 3.3 0.000184 3.3 0.000184005 0 0.0001845 0 0.000184505 3.3 0.000185 3.3 0.000185005 0 0.0001855 0 0.000185505 3.3 0.000186 3.3 0.000186005 0 0.0001865 0 0.000186505 3.3 0.000187 3.3 0.000187005 0 0.0001875 0 0.000187505 3.3 0.000188 3.3 0.000188005 0 0.0001885 0 0.000188505 3.3 0.000189 3.3 0.000189005 0 0.0001895 0 0.000189505 3.3 0.00019 3.3 0.000190005 0 0.0001905 0 0.000190505 3.3 0.000191 3.3 0.000191005 0 0.0001915 0 0.000191505 3.3 0.000192 3.3 0.000192005 0 0.0001925 0 0.000192505 3.3 0.000193 3.3 0.000193005 0 0.0001935 0 0.000193505 3.3 0.000194 3.3 0.000194005 0 0.0001945 0 0.000194505 3.3 0.000195 3.3 0.000195005 0 0.0001955 0 0.000195505 3.3 0.000196 3.3 0.000196005 0 0.0001965 0 0.000196505 3.3 0.000197 3.3 0.000197005 0 0.0001975 0 0.000197505 3.3 0.000198 3.3 0.000198005 0 0.0001985 0 0.000198505 3.3 0.000199 3.3 0.000199005 0 0.0001995 0 0.000199505 3.3 0.0002 3.3 0.000200005 0 0.0002005 0 0.000200505 3.3 0.000201 3.3 0.000201005 0 0.0002125 0 0.000212505 3.3 0.000213 3.3 0.000213005 0 0.0002135 0 0.000213505 3.3 0.000214 3.3 0.000214005 0 0.0002145 0 0.000214505 3.3 0.000215 3.3 0.000215005 0 0.0002155 0 0.000215505 3.3 0.000216 3.3 0.000216005 0 0.0002165 0 0.000216505 3.3 0.000217 3.3 0.000217005 0 0.0002175 0 0.000217505 3.3 0.000218 3.3 0.000218005 0 0.0002185 0 0.000218505 3.3 0.000219 3.3 0.000219005 0 0.0002195 0 0.000219505 3.3 0.00022 3.3 0.000220005 0 0.0002205 0 0.000220505 3.3 0.000221 3.3 0.000221005 0 0.0002215 0 0.000221505 3.3 0.000222 3.3 0.000222005 0 0.0002225 0 0.000222505 3.3 0.000223 3.3 0.000223005 0 0.0002235 0 0.000223505 3.3 0.000224 3.3 0.000224005 0 0.0002245 0 0.000224505 3.3 0.000225 3.3 0.000225005 0 0.0002255 0 0.000225505 3.3 0.000226 3.3 0.000226005 0 0.0002265 0 0.000226505 3.3 0.000227 3.3 0.000227005 0 0.0002275 0 0.000227505 3.3 0.000228 3.3 0.000228005 0 0.0002285 0 0.000228505 3.3 0.000229 3.3 0.000229005 0 0.0002295 0 0.000229505 3.3 0.00023 3.3 0.000230005 0 0.0002305 0 0.000230505 3.3 0.000231 3.3 0.000231005 0 0.0002425 0 0.000242505 3.3 0.000243 3.3 0.000243005 0 0.0002435 0 0.000243505 3.3 0.000244 3.3 0.000244005 0 0.0002445 0 0.000244505 3.3 0.000245 3.3 0.000245005 0 0.0002455 0 0.000245505 3.3 0.000246 3.3 0.000246005 0 0.0002465 0 0.000246505 3.3 0.000247 3.3 0.000247005 0 0.0002475 0 0.000247505 3.3 0.000248 3.3 0.000248005 0 0.0002485 0 0.000248505 3.3 0.000249 3.3 0.000249005 0 0.0002495 0 0.000249505 3.3 0.00025 3.3 0.000250005 0 0.0002505 0 0.000250505 3.3 0.000251 3.3 0.000251005 0 0.0002515 0 0.000251505 3.3 0.000252 3.3 0.000252005 0 0.0002525 0 0.000252505 3.3 0.000253 3.3 0.000253005 0 0.0002535 0 0.000253505 3.3 0.000254 3.3 0.000254005 0 0.0002545 0 0.000254505 3.3 0.000255 3.3 0.000255005 0 0.0002555 0 0.000255505 3.3 0.000256 3.3 0.000256005 0 0.0002565 0 0.000256505 3.3 0.000257 3.3 0.000257005 0 0.0002575 0 0.000257505 3.3 0.000258 3.3 0.000258005 0 0.0002585 0 0.000258505 3.3 0.000259 3.3 0.000259005 0 0.0002595 0 0.000259505 3.3 0.00026 3.3 0.000260005 0 0.0002605 0 0.000260505 3.3 0.000261 3.3 0.000261005 0)
Vdin din 0 PWL(0 0 2e-06 0 2.005e-06 3.3 4e-06 3.3 4.005e-06 0 3.2e-05 0 3.2005e-05 3.3 3.4e-05 3.3 3.4005e-05 0 3.6e-05 0 3.6005e-05 3.3 3.7e-05 3.3 3.7005e-05 0 6.2e-05 0 6.2005e-05 3.3 6.4e-05 3.3 6.4005e-05 0 6.5e-05 0 6.5005e-05 3.3 6.6e-05 3.3 6.6005e-05 0 9.2e-05 0 9.2005e-05 3.3 9.4e-05 3.3 9.4005e-05 0 9.5e-05 0 9.5005e-05 3.3 9.7e-05 3.3 9.7005e-05 0 0.000122 0 0.000122005 3.3 0.000125 3.3 0.000125005 0 0.000152 0 0.000152005 3.3 0.000155 3.3 0.000155005 0 0.000156 0 0.000156005 3.3 0.000157 3.3 0.000157005 0 0.000182 0 0.000182005 3.3 0.000186 3.3 0.000186005 0 0.000212 0 0.000212005 3.3 0.000217 3.3 0.000217005 0 0.000242 0 0.000242005 3.3 0.000247 3.3 0.000247005 0)
.control
tran 2n 0.000272 0 20n uic
.endc
.end
