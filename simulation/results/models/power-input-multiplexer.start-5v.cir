* Multiplexer: soft start at 5 V
.include "../../models/power_input.lib"
XU5 in1 in2 out pr1 in1 st 0 PWRIN_TPS2116
Vin in1 0 PWL(0 0 0.0001 0 0.00011 5)
Rpr in1 pr1 1
Rin2 in2 0 1k
Rst st in1 10k
Rout out 0 100
Cout out 0 10u
.control
tran 2e-06 0.005 0 2e-06 uic
.endc
.end
