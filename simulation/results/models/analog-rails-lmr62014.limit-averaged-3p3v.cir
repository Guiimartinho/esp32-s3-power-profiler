* LMR62014_AVG: current limit at 3.3 V of supply, output held at 12 V
.include "../../models/analog_rails.lib"
Vin vin 0 PWL(0 0 20u 3.3)
Ren vin en 51k
* (no inductor: averaged)
X1 sw 0 fb en vin LMR62014_AVG
Rfb fb 0 1k
D1 sw o B0530W
Vclamp o 0 12
.control
save sw vin i(Vclamp) i(Vin)
tran 1u 0.6m 0 1u
.endc
.end
