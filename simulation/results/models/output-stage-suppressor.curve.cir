* PTVS15VS1UR: voltage against forced current
.include "../../models/output_stage.lib"
XD21 0 k OUTPUT_PTVS15V
* a current source from the anode (ground) into the cathode: a positive
* value is a reverse current, a negative value a forward current
Itest 0 k 1m
.control
foreach level 0.001 16.4 -0.1 -1 -10 1e-06 1.46532e-06 2.14716e-06 3.14628e-06 4.61031e-06 6.75558e-06 9.89908e-06 1.45053e-05 2.12549e-05 3.11453e-05 4.56378e-05 6.6874e-05 9.79919e-05 0.000143589 0.000210404 0.00030831 0.000451773 0.000661992 0.00097003 0.0014214 0.00208281 0.00305199 0.00447214 0.00655311 0.0096024 0.0140706 0.0206179 0.0302119 0.04427 0.0648698 0.095055 0.139286 0.204099 0.29907 0.438233 0.642151 0.940957 1.3788 2.02039 2.96052 4.3381 6.35671 9.31462 13.6489 20 -0.0001 -0.000136749 -0.000187003 -0.000255724 -0.0003497 -0.000478211 -0.000653948 -0.000894266 -0.0012229 -0.0016723 -0.00228685 -0.00312725 -0.00427648 -0.00584804 -0.00799712 -0.010936 -0.0149548 -0.0204506 -0.0279659 -0.0382431 -0.052297 -0.0715156 -0.0977968 -0.133736 -0.182883 -0.25009 -0.341995 -0.467675 -0.63954 -0.874564 -1.19596 -1.63546 -2.23647 -3.05835 -4.18226 -5.71919 -7.82093 -10.695 -14.6253 -20
  alter Itest dc = $level
  op
end
.endc
.end
