* BC847B: gain and base-emitter voltage
.include "../../models/path_switching.lib"
QQ7 c b e PATH_BC847B
* the collector current is forced; an ideal amplifier drives the base
* until the collector stands at 5 V
Ve e 0 0
V5 v5 0 5
Ic 0 c 2m
Eservo drive 0 c v5 1e4
Vib drive b 0
.control
foreach level 2m 10m 1e-05 1.25899e-05 1.58507e-05 1.99559e-05 2.51244e-05 3.16315e-05 3.98239e-05 5.01381e-05 6.31236e-05 7.94723e-05 0.000100055 0.000125969 0.000158594 0.000199669 0.000251383 0.000316489 0.000398459 0.000501657 0.000631584 0.000795161 0.0010011 0.00126038 0.00158682 0.0019978 0.00251521 0.00316664 0.00398678 0.00501934 0.00631933 0.007956 0.0100166 0.0126108 0.0158769 0.019989 0.025166 0.0316839 0.0398898 0.0502211 0.0632281 0.0796039 0.100221 0.126178 0.158857 0.2
  alter Ic dc = $level
  op
end
.endc
.end
