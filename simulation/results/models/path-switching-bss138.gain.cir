* BSS138: transfer curve
.include "../../models/path_switching.lib"
MQ2 d g 0 PATH_BSS138
* drain at 25 V, gate swept
Vd d 0 25
Vg g 0 2.5
.control
dc Vg 0.5 3.5 0.005
.endc
.end
