* ADS8860 digital pins: one frame in the three-wire mode into 20 pF
.include "../../models/digital.lib"
* supply 3.0 V; 20 pF at DOUT as in the load circuit of the datasheet;
* two resistors hold DOUT at half the supply while it is open
Vdd dvdd 0 3
X1 cnv dout sck dvdd dvdd 0 DIGITAL_ADS8860_IO code=42435
Cl dout 0 20p
Rup dvdd dout 5k
Rdn dout 0 5k
Vcnv cnv 0 PWL(0 0 5e-08 0 5.1e-08 3 8e-07 3 8.01e-07 0 2.05u 0 2.051u 3)
Vsck sck 0 PULSE(0 3 8.06666e-07 1n 1n 3.23335e-08 6.6667e-08 16)
.control
tran 0.05n 2.2u 0 0.5n
.endc
.end
