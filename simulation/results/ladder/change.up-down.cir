* Range change at the ladder: range 1 to range 2 and back at 2 mA
.include "../../models/logic.lib"
.include "../../models/sequencer.lib"
.include "../../models/mosfets.lib"
.include "../../models/mux509.lib"
C62 supply 0 1e-06
C63 n_c63_pad1 0 4.7e-06
C64 p12v_a 0 1e-06
C65 p12v_a 0 1e-06
C66 p12v_a 0 1e-07
C67 p12v_a 0 1e-07
C68 p12v_a 0 1e-07
C69 0 m4v_a 1e-07
C71 vout_s 0 1e-07
MQ10 supply n_q10_g vout_s IRLML0030_CLAMP
MQ11 supply n_q11_g vout_s IRLML0030_CLAMP
MQ12 supply g_r1 sense_r1 IRLML0030
MQ13 supply g_r2 sense_r2 IRLML0030
MQ14 supply g_r3 sense_r3 CSD17577Q3A
R87 supply n_c63_pad1 0.47
R88 gate_r3 0 1000
R89 gate_r1 0 1000
R90 supply 0 100000
R91 mux_a1 0 5100
R92 supply n_q10_g 22
R93 gate_out 0 1000
R94 gate_r2 0 1000
R95 mux_a0 0 5100
R96 gate_r3 n_u22_in_b 1000
R97 gate_r1 n_u23_in_b 1000
R98 gate_out n_u22_in_a 1000
R99 gate_r2 n_u23_in_a 1000
XU22_1 n_u22_in_a drv_out p12v_a 0 TC4427CH
XU22_2 n_u22_in_b n_u22_out_b p12v_a 0 TC4427CH
XU23_1 n_u23_in_a n_u23_out_a p12v_a 0 TC4427CH
XU23_2 n_u23_in_b n_u23_out_b p12v_a 0 TC4427CH
XU24 n_u24_a0 n_u24_en m4v_a supply sense_r1 n_u24_s3a n_u24_s4a inp inn n_u24_s4b n_u24_s3b vout_s vout_s p12v_a 0 n_u24_a1 MUX509
R100 supply n_q11_g 22
R101 supply vout_s 1000
R102 n_u23_out_b g_r1 47
R103 g_r1 0 100000
R104 sense_r1 vout_s 33
R105 n_u23_out_a g_r2 47
R106 g_r2 0 100000
R107 sense_r2 vout_s 1
RR107_SA sense_r2 n_u24_s3a 0.001
RR107_SB vout_s n_u24_s3b 0.001
R108 n_u22_out_b g_r3 10
R109 g_r3 0 100000
R110 sense_r3 vout_s 0.1
RR110_SA sense_r3 n_u24_s4a 0.001
RR110_SB vout_s n_u24_s4b 0.001
R111 mux_a1 n_u24_a1 1000
R112 mux_a0 n_u24_a0 1000
R113 p12v_a n_u24_en 10000
* ideal rails
Vp12 p12v_a 0 12
Vm4 m4v_a 0 -4
Vp3v3a p3v3_a 0 3.3
* range sequencer: model of rules F-16 to F-18, not a program
Xseq seq_up seq_jump seq_oc seq_down seq_enable seq_out_on gate_r1 gate_r2 gate_r3 mux_a0 mux_a1 gate_out SEQUENCER tseq=1e-07 toverlap=1e-06 tblank=2e-06 toc=1.2e-05
* the source meter as an ideal 5 V source, the load as a current sink
* with the 1 uF of requirement R-07 beside it
Vsupply supply 0 5
Iload vout_s 0 PWL(0 50u 6u 50u 7u 0.002)
Cdut vout_s 0 1e-06
* commands: up to range 1 at 2 us, up to range 2, down to range 1
Vup seq_up 0 PWL(0 0 2u 0 2.01u 3.3 2.5u 3.3 2.51u 0 1.5e-05 0 1.501e-05 3.3 1.55e-05 3.3 1.551e-05 0)
Vdown seq_down 0 PULSE(0 3.3 3e-05 10n 10n 0.5u 1)
Vjump seq_jump 0 0
Voc seq_oc 0 0
Venable seq_enable 0 3.3
Vouton seq_out_on 0 0
.control
save all @r101[i] @r104[i] @r107[i]
tran 5n 0.00023
.endc
.end
