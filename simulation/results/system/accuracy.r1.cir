* Whole measuring path, range 1 held, load stepped through the range
.include "../../models/diodes.lib"
.include "../../models/mosfets.lib"
.include "../../models/logic.lib"
.include "../../models/mux509.lib"
.include "../../models/opamps.lib"
.include "../../models/ad8421.lib"
C62 supply 0 1e-06
C63 n_c63_pad1 0 4.7e-06
C64 p12v_a 0 1e-06
C65 p12v_a 0 1e-06
C66 p12v_a 0 1e-07
C67 p12v_a 0 1e-07
C68 p12v_a 0 1e-07
C69 0 m4v_a 1e-07
C71 vout_s 0 1e-07
C75 inn 0 2.2e-11
C76 inp 0 2.2e-11
C77 inp inn 2.2e-10
C78 n_u26_p 0 1e-06
C79 p12v_a 0 1e-07
C80 p12v_a 0 1e-07
C81 0 m4v_a 1e-07
C82 0 m4v_a 1e-06
C83 p12v_a 0 1e-06
C84 0 m4v_a 1e-07
C85 lim n_u29_n 1.5e-09
C86 p3v3_a 0 1e-07
C87 n_u29_p 0 6.8e-10
C88 vdrv 0 1e-07
C89 n_c89_pad1 0 2.2e-05
C90 adc_in 0 1e-08
C93 th_jump 0 1e-07
C94 th_oc 0 1e-07
C95 th_up 0 1e-07
C96 p3v3_a 0 1e-07
C97 p3v3_a 0 1e-07
DD22_1 0 lim BAV199
DD22_2 lim vdrv BAV199
DD23_1 0 cmp_in BAV199
DD23_2 cmp_in p3v3_a BAV199
MQ10 supply n_q10_g vout_s IRLML0030_CLAMP
MQ11 supply n_q11_g vout_s IRLML0030_CLAMP
MQ12 supply g_r1 sense_r1 IRLML0030
MQ13 supply g_r2 sense_r2 IRLML0030
MQ14 supply g_r3 sense_r3 CSD17577Q3A
R87 supply n_c63_pad1 0.47
R88 gate_r3 0 1000
R89 gate_r1 0 1000
R90 supply 0 100000
R91 mux_a1 0 5100
R92 supply n_q10_g 22
R93 gate_out 0 1000
R94 gate_r2 0 1000
R95 mux_a0 0 5100
R96 gate_r3 n_u22_in_b 1000
R97 gate_r1 n_u23_in_b 1000
R98 gate_out n_u22_in_a 1000
R99 gate_r2 n_u23_in_a 1000
XU22_1 n_u22_in_a drv_out p12v_a 0 TC4427CH
XU22_2 n_u22_in_b n_u22_out_b p12v_a 0 TC4427CH
XU23_1 n_u23_in_a n_u23_out_a p12v_a 0 TC4427CH
XU23_2 n_u23_in_b n_u23_out_b p12v_a 0 TC4427CH
XU24 n_u24_a0 n_u24_en m4v_a supply sense_r1 n_u24_s3a n_u24_s4a inp inn n_u24_s4b n_u24_s3b vout_s vout_s p12v_a 0 n_u24_a1 MUX509
XU26 n_u26_p ped p12v_a m4v_a ped OPA197
XU27 inn n_r123_pad1 n_r123_pad2 inp m4v_a ped amp_raw p12v_a AD8421
XU28 n_u28_p n_u28_n p3v3_a 0 n_r127_pad1 OPA365
XU29 n_u29_p n_u29_n vdrv 0 n_u29_n OPA365
R100 supply n_q11_g 22
R101 supply vout_s 1000
R102 n_u23_out_b g_r1 47
R103 g_r1 0 100000
R104 sense_r1 vout_s 33
R105 n_u23_out_a g_r2 47
R106 g_r2 0 100000
R107 sense_r2 vout_s 1
RR107_SA sense_r2 n_u24_s3a 0.001
RR107_SB vout_s n_u24_s3b 0.001
R108 n_u22_out_b g_r3 10
R109 g_r3 0 100000
R110 sense_r3 vout_s 0.1
RR110_SA sense_r3 n_u24_s4a 0.001
RR110_SB vout_s n_u24_s4b 0.001
R111 mux_a1 n_u24_a1 1000
R112 mux_a0 n_u24_a0 1000
R113 p12v_a n_u24_en 10000
R121 vref n_u26_p 49900
R122 n_u26_p 0 1020
R123 n_r123_pad1 n_r123_pad2 523
R124 n_u28_n 0 11000
R125 amp_raw lim 3900
R126 vref n_u28_p 10000
R127 n_r127_pad1 n_u28_n 1000
R128 lim n_u29_p 3900
R129 n_r127_pad1 vdrv 10
R130 n_u29_n adc_in 22
R131 vref n_c89_pad1 0.22
R132 vref th_jump 34800
R133 th_jump th_oc 3600
R134 th_oc th_up 2400
R135 th_up 0 9310
R136 amp_raw cmp_in 3010
R137 cmp_in 0 1000
* ideal rails
Vp12 p12v_a 0 12
Vm4 m4v_a 0 -4
Vp3v3a p3v3_a 0 3.3
Vref vref 0 2.5
* controller lines held for range 1
Vgate_r1 gate_r1 0 3.3
Vgate_r2 gate_r2 0 0
Vgate_r3 gate_r3 0 0
Vmux_a0 mux_a0 0 3.3
Vmux_a1 mux_a1 0 0
Vgate_out gate_out 0 0
* the source meter as an ideal 5 V source on the supply node; the
* load as a current sink on the node after the shunts, stepped
* through its levels as a staircase and read at the end of each
Vsupply supply 0 5
Iload vout_s 0 PWL(0 0 0.00015 0 0.000155 3e-06 0.0003 3e-06 0.000305 3.9009e-06 0.00045 3.9009e-06 0.000455 5.07234e-06 0.0006 5.07234e-06 0.000605 6.59557e-06 0.00075 6.59557e-06 0.000755 8.57623e-06 0.0009 8.57623e-06 0.000905 1.11517e-05 0.00105 1.11517e-05 0.001055 1.45005e-05 0.0012 1.45005e-05 0.001205 1.8855e-05 0.00135 1.8855e-05 0.001355 2.45172e-05 0.0015 2.45172e-05 0.001505 3.18798e-05 0.00165 3.18798e-05 0.001655 4.14533e-05 0.0018 4.14533e-05 0.001805 5.39017e-05 0.00195 5.39017e-05 0.001955 7.00884e-05 0.0021 7.00884e-05 0.002105 9.1136e-05 0.00225 9.1136e-05 0.002255 0.000118504 0.0024 0.000118504 0.002405 0.000154091 0.00255 0.000154091 0.002555 0.000200365 0.0027 0.000200365 0.002705 0.000260534 0.00285 0.000260534 0.002855 0.000338773 0.003 0.000338773 0.003005 0.000440507 0.00315 0.000440507 0.003155 0.000572791 0.0033 0.000572791 0.003305 0.000744801 0.00345 0.000744801 0.003455 0.000968465 0.0036 0.000968465 0.003605 0.0012593 0.00375 0.0012593 0.003755 0.00163746 0.0039 0.00163746 0.003905 0.00212919 0.00405 0.00212919 0.004055 0.00276859 0.0042 0.00276859 0.004205 0.0036)
.control
save adc_in amp_raw inp inn supply vout_s
tran 1u 0.00435
.endc
.end
