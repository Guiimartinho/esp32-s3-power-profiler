* Converter input: sampling at 500 kSPS with 2.45 V at the input
.include "../../models/opamps.lib"
.include "../../models/diodes.lib"
.include "../../models/signal_chain.lib"
C85 lim adc_drv 1.5e-09
C86 p3v3_a 0 1e-07
C87 flt 0 6.8e-10
C88 vdrv 0 1e-07
C90 adc_in 0 1e-08
DD22_1 0 lim BAV199
DD22_2 lim vdrv BAV199
XU28 buf_p buf_n p3v3_a 0 buf_out OPA365
XU29 flt adc_drv vdrv 0 adc_drv OPA365
XU30 vref adc_in 0 0 cnv SIGNAL_CHAIN_ADS8860
R124 buf_n 0 11000
R125 amp_raw lim 3900
R126 vref buf_p 10000
R127 buf_out buf_n 1000
R128 lim flt 3900
R129 buf_out vdrv 10
R130 adc_drv adc_in 22
* ideal rails
Vp12 p12v_a 0 12
Vm4 m4v_a 0 -4
Vp3v3a p3v3_a 0 3.3
Vref vref 0 2.5
* the amplifier output as a source
Vamp amp_raw 0 2.45
* convert-start line at the pin of the converter
Vcnv cnv 0 PULSE(0 3.3 5e-06 5n 5n 1e-06 2e-06 16)
.options reltol=1e-5
.options vntol=1e-8
.options abstol=1e-13
.control
save adc_in adc_drv cnv vdrv xu30.shp xu30.q
tran 1n 3.7e-05 0 4n
.endc
.end
