* Driver rail buffer: load step on the rail
.include "../../models/opamps.lib"
.include "../../models/diodes.lib"
.include "../../models/signal_chain.lib"
C85 lim adc_drv 1.5e-09
C86 p3v3_a 0 1e-07
C87 flt 0 6.8e-10
C88 vdrv 0 1e-07
C90 adc_in 0 1e-08
DD22_1 0 lim BAV199
DD22_2 lim vdrv BAV199
XU28 buf_p buf_n p3v3_a 0 buf_out SIGNAL_CHAIN_OPA365_PROBE vac=0 iac=0
XU29 flt adc_drv vdrv 0 adc_drv OPA365
R124 buf_n 0 11000
R125 amp_raw lim 3900
R126 vref buf_p 10000
R127 buf_out buf_n 1000
R128 lim flt 3900
R129 buf_out vdrv 10
R130 adc_drv adc_in 22
* ideal rails
Vp12 p12v_a 0 12
Vm4 m4v_a 0 -4
Vp3v3a p3v3_a 0 3.3
Vref vref 0 2.5
* the amplifier output as a source; a load on the rail beside the driver
Vamp amp_raw 0 1
Iload vdrv 0 PWL(0 0 1e-05 0 1.002e-05 0.003)
.control
save vdrv buf_out buf_n buf_p adc_in
tran 2n 6e-05 0 5n
.endc
.end
