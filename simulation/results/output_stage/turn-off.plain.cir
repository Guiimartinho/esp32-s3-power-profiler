* Output switched off under load: 5 V, no inductance
.include "../../models/diodes.lib"
.include "../../models/output_stage.lib"
.include "../../models/mosfets.lib"
.include "../../models/logic.lib"
.include "../../models/mux509.lib"
.include "../../models/opamps.lib"
C62 supply 0 1e-06
C63 damper 0 4.7e-06
C64 p12v_a 0 1e-06
C65 p12v_a 0 1e-06
C66 p12v_a 0 1e-07
C67 p12v_a 0 1e-07
C68 p12v_a 0 1e-07
C69 0 m4v_a 1e-07
C70 p12v_a 0 1e-07
C71 vout_s 0 1e-07
C72 0 m4v_a 1e-07
C73 guard 0 1e-07
C74 out_gate 0 1e-08
DD20_1 0 out_gate BAV199
DD20_2 out_gate gate_off BAV199
XD21 0 vout OUTPUT_PTVS15V
MQ10 supply n_q10_g vout_s IRLML0030_CLAMP
MQ11 supply n_q11_g vout_s IRLML0030_CLAMP
MQ12 supply g_r1 sense_r1 IRLML0030
MQ13 supply g_r2 sense_r2 IRLML0030
MQ14 supply g_r3 sense_r3 CSD17577Q3A
MQ15 vout_s g_out mid CSD17577Q3A
MQ16 vout g_out mid CSD17577Q3A
R87 supply damper 0.47
R88 gate_r3 0 1000
R89 gate_r1 0 1000
R90 supply 0 100000
R91 mux_a1 0 5100
R92 supply n_q10_g 22
R93 gate_out 0 1000
R94 gate_r2 0 1000
R95 mux_a0 0 5100
R96 gate_r3 n_u22_in_b 1000
R97 gate_r1 n_u23_in_b 1000
R98 gate_out n_u22_in_a 1000
R99 gate_r2 n_u23_in_a 1000
XU22_1 n_u22_in_a drv_out p12v_a 0 TC4427CH
XU22_2 n_u22_in_b n_u22_out_b p12v_a 0 TC4427CH
XU23_1 n_u23_in_a n_u23_out_a p12v_a 0 TC4427CH
XU23_2 n_u23_in_b n_u23_out_b p12v_a 0 TC4427CH
XU24 n_u24_a0 n_u24_en m4v_a supply sense_r1 n_u24_s3a n_u24_s4a inp inn n_u24_s4b n_u24_s3b vout_s vout_s p12v_a 0 n_u24_a1 MUX509
XU25 buf_in buf_out p12v_a m4v_a buf_out OPA197
R100 supply n_q11_g 22
R101 supply vout_s 1000
R102 n_u23_out_b g_r1 47
R103 g_r1 0 100000
R104 sense_r1 vout_s 33
R105 n_u23_out_a g_r2 47
R106 g_r2 0 100000
R107 sense_r2 vout_s 1
RR107_SA sense_r2 n_u24_s3a 0.001
RR107_SB vout_s n_u24_s3b 0.001
R108 n_u22_out_b g_r3 10
R109 g_r3 0 100000
R110 sense_r3 vout_s 0.1
RR110_SA sense_r3 n_u24_s4a 0.001
RR110_SB vout_s n_u24_s4b 0.001
R111 mux_a1 n_u24_a1 1000
R112 mux_a0 n_u24_a0 1000
R113 p12v_a n_u24_en 10000
R114 vout_s buf_in 10000
R115 drv_out 0 100000
R116 drv_out gate_off 220
R117 drv_out out_gate 2.2e+06
R118 buf_out vccb_src 1000
R119 buf_out guard 47
R120 out_gate g_out 10
* ideal rails, risen from zero
Vp12 p12v_a 0 PWL(0 0 2e-05 12)
Vm4 m4v_a 0 PWL(0 0 2e-05 -4)
Vp3v3a p3v3_a 0 PWL(0 0 2e-05 3.3)
* controller lines held for range 3
Vgate_r1 gate_r1 0 0
Vgate_r2 gate_r2 0 0
Vgate_r3 gate_r3 0 PWL(0 0 2e-05 3.3)
Vmux_a0 mux_a0 0 PWL(0 0 2e-05 3.3)
Vmux_a1 mux_a1 0 PWL(0 0 2e-05 3.3)
* GATE_OUT: a pin of the controller behind its output resistance
Vcmd cmd 0 PWL(0 3.3 0.0002 3.3 0.00020002 0)
Rpad cmd gate_out 33
* stand-in for the source meter and the closed mode pair
Vsrc src 0 PWL(0 0 2e-05 5)
Rsrc src supply 0.01
* cable to the device under test
Vcab vout cab 0
Rcab cab dut 0.05
* device under test: a resistor that takes 1 A
Rload dut 0 4.835
* the gate node is brought to its rest value by a helper that opens before the
* event; through R117 alone the gate needs a quarter of a second
Vpre pre 0 PWL(0 0 2e-05 12)
Vprectl prectl 0 PWL(0 1 6e-05 1 6.01e-05 0)
Spre out_gate pre prectl 0 OUTPUT_PRECHARGE
.model OUTPUT_PRECHARGE SW(vt=0.5 vh=0.1 ron=100 roff=1e12)
.options method=gear
.control
save gate_out drv_out out_gate g_out mid vout_s vout dut supply guard @r110[i] vcab#branch @r.xd21.rf[i] v.xd21.vz#branch @mq15[id]
tran 5n 0.00028 0 10n uic
.endc
.end
