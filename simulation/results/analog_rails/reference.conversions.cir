* Reference line: start and the conversions of the converter
.include "../../models/analog_rails.lib"
DD7 vref p3v3_a B0530W
XC20 ref_in 0 RAILS_MLCC c=4.7u v0=8
C24 ref_nr 0 1e-06
C26 ref_c26 0 1e-05
C89 ref_c89 0 2.2e-05
R31 p3v3_a ref_in 10
R35 vref ref_c26 1
R49 vref sense_vref 36500
R50 sense_vref 0 100000
R55 vref dac_ref 2000
R56 dac_ref 0 2000
XU12 ref_in 0 ref_nr vref REF5025AID
C113 vref 0 1e-07
R131 vref ref_c89 0.22
R148 vref mon_m4 100000
R153 mon_m4 m4v_a 200000
V3a p3v3_a 0 PWL(0 0 0.1m 3.3)
Vm4 m4v_a 0 PWL(0 0 0.1m -4)
Iload vref 0 0.00012
* the reference input of the converter: 300 pC per conversion, from 250 ms on
Iadc ref_c89 0 PULSE(0 0.0006 0.25 20n 20n 5e-07 1e-05)
.options reltol=1e-6
.options vntol=10n
.options abstol=1p
.control
save vref ref_c89 ref_in ref_nr p3v3_a
tran 1u 0.2531 0 20u
.endc
.end
