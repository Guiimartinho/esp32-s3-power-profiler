* Loop gain at 5 V, 600 mA, range 3, 10 uF at the device
.include "../../models/source_meter.lib"
.include "../../models/diodes.lib"
.include "../../models/opamps.lib"
XL2 sw_l1 sw_l2 XFL4020_152
MQ1 smu_on ok_5v smu_en SOURCE_METER_BSS138
C36 p3v3_a 0 1e-07
C37 vina 0 1e-07
C38 dac_ref 0 1e-07
C39 p5v 0 4.97e-06
C40 p5v 0 4.97e-06
C41 dac_filt 0 9.58238e-07
C42 v_pre 0 1.27649e-05
C43 ldo_in damper 1.27649e-05
C44 p12v_a 0 1e-07
C45 v_pre 0 1.27649e-05
C46 ldo_in 0 4.5632e-06
C47 vctl 0 5e-07
C48 0 m4v_a 1e-07
C49 ldo_set 0 1e-07
C50 v_pre 0 1.27649e-05
C51 p3v3_a 0 1e-07
C52 trk_n pre_fb 1e-11
C53 ldo_out 0 1.364e-05
C54 ldo_out 0 1e-07
C55 trk_sense 0 1e-07
C62 supply 0 8.25e-07
C63 supply_damper 0 3.3652e-06
C71 vout_s 0 1e-07
DD10_1 vctl_feed vctl BAV199
DD10_2 vctl vctl BAV199
DD11 ldo_out ldo_in SOURCE_METER_1N5819HW
DD12 0 ldo_out SOURCE_METER_1N5819HW
DD13_1 ldo_out trk_sense BAV199
DD13_2 trk_sense trk_sense BAV199
XFB1 v_pre ldo_in BLM31SN500
R53 smu_en 0 1000
R54 dac_out dac_filt 10000
R55 vref dac_ref 2000
R56 dac_ref 0 2000
R57 set_fb 0 10000
R58 set_drv set_fb 11000
R59 damper 0 0.33
R60 set_drv ldo_set 1000
R61 p13v5 vctl_feed 10
R62 v_pre 0 1000
R63 trk_n pre_fb 19100
R64 trk_sense trk_n 93100
R65 ldo_out trk_sense 6650
R66 trk_p 0 23700
R67 v_pre trk_p 100000
R68 vref trk_p 137000
R69 ldo_out m4v_a 1300
R87 supply supply_damper 0.47
R90 supply 0 100000
XU15 p3v3_a dac_ref dac_out 0 MCP4921 code=3893
XU16 p5v vina smu_en vina pre_fb v_pre sw_l1 sw_l2 pg_open 0 0 TPS63020_AVG vac=1
XU17 dac_filt set_fb p12v_a m4v_a set_drv OPA197
XU18 ldo_in vctl ldo_set ldo_out LT3080
XU19 trk_p trk_n p3v3_a 0 pre_fb OPA365
* ideal rails: the circuits that make them belong to other blocks
Vp5 p5v 0 5
Vp13 p13v5 0 13.5
Vp12 p12v_a 0 12
Vm4 m4v_a 0 -4
Vp3v3a p3v3_a 0 3.3
Vref vref 0 2.5
* SMU_ON: a pin of the controller behind its output resistance
Vsmu smu_pin 0 3.3
Rsmu smu_pin smu_on 33
* 5V_OK: released by the supervisor, pulled up by R25 against its loads
Vok ok_5v 0 4.717
* the path to the device under test, as three resistors: the closed
* source pair, the shunt of the range with its switch, the closed
* output pair with copper and contacts
Rpair ldo_out supply 0.0106
Rshunt supply vout_s 0.1041
Rpath vout_s dut 0.0306
* the device under test: a current sink and its capacitor
Iload dut 0 0.6
Cdut dut dut_c 1e-05
Rdut dut_c 0 0.005
.nodeset v(dut_c)=-1.38820899e-12
.nodeset v(dut)=4.9121673
.nodeset v(smu_pin)=3.3
.nodeset v(xu19.x1.yb)=0.498426087
.nodeset v(xu19.x1.y)=0.498426087
.nodeset v(xu19.x1.y1)=0.498426087
.nodeset v(xu19.x1.io)=-3.7860067e-05
.nodeset v(xu19.x1.x)=0.498426087
.nodeset v(xu19.x1.ip)=1.22271232
.nodeset v(xu19.x1.ip1)=1.22271232
.nodeset v(xu19.x1.ip0)=1.22271232
.nodeset v(xu19.x1.xn.n7)=0
.nodeset v(xu19.x1.xn.n6)=0
.nodeset v(xu19.x1.xn.n5)=0
.nodeset v(xu19.x1.xn.n4)=0
.nodeset v(xu19.x1.xn.n3)=0
.nodeset v(xu19.x1.xn.n2)=0
.nodeset v(xu19.x1.xn.n1)=0
.nodeset v(xu19.x1.nf)=0
.nodeset v(xu19.x1.nw)=0
.nodeset v(xu18.e)=5.03574787
.nodeset v(xu18.c)=5.35814313
.nodeset v(xu18.c1)=5.42355776
.nodeset v(xu18.c0)=5.44855776
.nodeset v(xu18.b)=5.82634944
.nodeset v(xu18.cmd)=5.89828783
.nodeset v(xu18.xref)=5.61979417
.nodeset v(xu18.x)=5.89650262
.nodeset v(xu18.e2)=0.00044633688
.nodeset v(xu18.e1b)=0.00044633688
.nodeset v(xu18.e1)=0.00044633688
.nodeset v(xu18.err)=0.000446336876
.nodeset v(xu18.sns)=4.99934783
.nodeset v(xu18.nz)=0
.nodeset v(xu18.ns)=0
.nodeset v(xu17.x1.yb)=5.07511564
.nodeset v(xu17.x1.y)=5.07511564
.nodeset v(xu17.x1.y1)=5.07511564
.nodeset v(xu17.x1.io)=0.000227523927
.nodeset v(xu17.x1.x)=5.07511564
.nodeset v(xu17.x1.ip)=2.37609345
.nodeset v(xu17.x1.ip1)=2.37609345
.nodeset v(xu17.x1.ip0)=2.37609345
.nodeset v(xu17.x1.xn.n7)=0
.nodeset v(xu17.x1.xn.n6)=0
.nodeset v(xu17.x1.xn.n5)=0
.nodeset v(xu17.x1.xn.n4)=0
.nodeset v(xu17.x1.xn.n3)=0
.nodeset v(xu17.x1.xn.n2)=0
.nodeset v(xu17.x1.xn.n1)=0
.nodeset v(xu17.x1.nf)=0
.nodeset v(xu17.x1.nw)=0
.nodeset v(xu16.sw2)=4.92401261
.nodeset v(xu16.d2)=0.0964300854
.nodeset v(xu16.d1)=1
.nodeset v(xu16.us)=1.09643009
.nodeset v(xu16.ss1)=2.95
.nodeset v(xu16.uff)=1.08248619
.nodeset v(xu16.sw1a)=5
.nodeset v(xu16.sw1)=5
.nodeset v(xu16.icmd)=0.658544198
.nodeset v(xu16.u)=1.09643009
.nodeset v(xu16.ss)=2.95
.nodeset v(xu16.xi)=0.638327371
.nodeset v(xu16.ev)=0.000438110755
.nodeset v(xu16.fbs)=0.499561889
.nodeset v(xu16.lim)=4
.nodeset v(xu16.enf)=1
.nodeset v(xu16.en1)=1
.nodeset v(pg_open)=0
.nodeset v(xu15.o)=2.37609825
.nodeset v(xu15.s)=2.37609825
.nodeset v(xu15.tgt)=2.37609863
.nodeset v(xu15.xc)=0.950439453
.nodeset v(xu15.rb)=1.25
.nodeset v(xu15.act)=1
.nodeset v(xu15.a1)=1
.nodeset v(xu15.cd)=3893
.nodeset v(trk_p)=1.22271232
.nodeset v(p13v5)=13.5
.nodeset v(set_drv)=4.98979417
.nodeset v(set_fb)=2.37609244
.nodeset v(vref)=2.5
.nodeset v(dac_out)=2.3760935
.nodeset v(xfb1.m)=5.44855776
.nodeset v(vctl_feed)=13.3765808
.nodeset v(vout_s)=4.9305273
.nodeset v(supply_damper)=4.9929873
.nodeset v(supply)=4.9929873
.nodeset v(trk_sense)=4.74759447
.nodeset v(ldo_out)=4.99934783
.nodeset v(pre_fb)=0.499561889
.nodeset v(trk_n)=1.22271182
.nodeset v(ldo_set)=4.99979417
.nodeset v(m4v_a)=-4
.nodeset v(vctl)=12.4549193
.nodeset v(p12v_a)=12
.nodeset v(damper)=-1.36637368e-11
.nodeset v(ldo_in)=5.44855776
.nodeset v(v_pre)=5.44950925
.nodeset v(dac_filt)=2.37609345
.nodeset v(p5v)=5
.nodeset v(dac_ref)=1.25
.nodeset v(vina)=4.9999995
.nodeset v(p3v3_a)=3.3
.nodeset v(smu_en)=3.15739133
.nodeset v(ok_5v)=4.717
.nodeset v(smu_on)=3.19580609
.nodeset v(sw_l2)=4.95722389
.nodeset v(xl2.m)=4.96678872
.nodeset v(sw_l1)=4.96678872
.control
ac dec 50 10 20meg
.endc
.end
